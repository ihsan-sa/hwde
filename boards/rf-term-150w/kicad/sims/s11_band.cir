* rf-term-150w - BENCH 1: return loss vs frequency, 20-30 MHz, trimmer FIXED
*
* SOURCE TOPOLOGY. P2 feasibility bench - there is no exported kicad/*.net yet
* (kicad/ holds only constraints.json + lib tables), so the network is taken
* from architecture/blocks.md s2 + s4 and is the WHOLE dynamic board:
*     PORT --+-- L_launch -- R_term -- GND (flange straps)
*            +-- (C_trim || C_pad) -- GND
* No rename map applies (no netlist); the eventual schematic nets are /RF (node
* "p" of each X instance) and GND (node 0) per kicad/constraints.json.
*
* MODEL PROVENANCE (generic, datasheet-derived; NO vendored vendor models -
* every element here is an ideal R/L/C, which is the honest model for a passive
* one-port two orders of magnitude below any self-resonance):
*   R_term  50 ohm +/-5% catalogue (Vishay/Barry T50R0-250-12X, parts/
*           T50R0-250-12X.json); select-on-test narrows to 49.0-51.0 at build
*           (P1 decision, decisions.md). Builds below: 50.0 / 51.0 / 52.5.
*   L_launch total residual series inductance, architect's term-by-term budget
*           = 6.9 nH (blocks.md s4.2). Term E (strap/via return loop) is the
*           lowest-confidence term and could push the total to 8.4 nH
*           (blocks.md s8 OPEN-5) - build C uses that value.
*   C_pad   1.3 pF of unavoidable mounting/pad parasitic in parallel with the
*           trimmer (blocks.md s4.3 stub + pad terms). NOT adjustable.
*   C_trim  PARAMETERISED, not a part number: the trimmer is being re-selected
*           for a temperature reason (blocks.md s8 OPEN-1). Only cmin/cmax
*           below define its range - edit those two lines to re-evaluate any
*           candidate part. Currently 1-35 pF.
*
* METHOD. ngspice .ac cannot post-process complex vectors, so S11 is formed by
* the network itself: an ideal 2 V AC source behind exactly z0 = 50 ohm makes
* the incident wave 1 V, so v(dut) = 1 + Gamma. A second source holds a 1 V
* reference and a UNITY VCVS (linear -> exact in .ac) subtracts it, so the node
* g* carries Gamma directly and vdb(g*) = -RL in dB. Verified against a closed
* form (Zin = R+jwL shunted by C, Gamma = (Z-z0)/(Z+z0)): 72.583 vs 72.5845 dB.
*
* DESIGN INTENT / what this bench proves. The operator tunes ONCE at Fc =
* 25.0 MHz. C_trim is therefore a CONSTANT in this netlist - only the frequency
* sweeps - so the band numbers cannot be flattered by re-optimising per point.
* The setting used is the exact susceptance null B = X/(R^2+X^2) at 25.0 MHz,
* clamped to the trimmer range; that null is the global |Gamma| minimum for a
* shunt-C-only tuner (proved by sweep in tuning_authority.cir).
* Asserts requirements crit. 2 (RL >= 26 dB at 25.0 MHz) and crit. 3
* (RL >= 20 dB over 22.5-27.5 MHz) at three resistance builds.

.param z0=50
.param fc=25e6
.param w0={2*3.141592653589793*fc}
.param cpad=1.3e-12
.param cmin=1e-12
.param cmax=35e-12

* exact susceptance null at fc, and the trimmer setting that realises it
.func copt(rr,ll) {ll/(rr*rr+(w0*ll)*(w0*ll))}
.func ctset(rr,ll) {min(cmax,max(cmin,copt(rr,ll)-cpad))}

.subckt oneport p lval=6.9n rval=50 cval=1.5p cpv=1.3p
Ll p m {lval}
Rt m 0 {rval}
Ct p 0 {cval}
Cp p 0 {cpv}
.ends

Vsrc src 0 AC 2
Vref ref 0 AC 1

* --- build A: nominal, R = 50.0 ohm, L = 6.9 nH -------------------------
.param ra=50.0
.param la=6.9n
.param cta={ctset(ra,la)}
Rsa src da {z0}
Xa da oneport lval={la} rval={ra} cval={cta} cpv={cpad}
Ea ga 0 da ref 1

* --- build B: select-on-test upper limit, R = 51.0 ohm, L = 6.9 nH ------
.param rb=51.0
.param lb=6.9n
.param ctb={ctset(rb,lb)}
Rsb src db {z0}
Xb db oneport lval={lb} rval={rb} cval={ctb} cpv={cpad}
Eb gb 0 db ref 1

* --- build C: worst case, catalogue +5% R and the high L estimate -------
.param rc=52.5
.param lc=8.4n
.param ctc={ctset(rc,lc)}
Rsc src dc {z0}
Xc dc oneport lval={lc} rval={rc} cval={ctc} cpv={cpad}
Ec gc 0 dc ref 1

.ac lin 1001 20e6 30e6

.meas ac s_a_fc   find vdb(ga) at=25e6
.meas ac rl_a_fc   param='-s_a_fc'
.meas ac s_a_band  max vdb(ga) from=22.5e6 to=27.5e6
.meas ac rl_a_band param='-s_a_band'
.meas ac s_a_full  max vdb(ga) from=20e6 to=30e6
.meas ac rl_a_full param='-s_a_full'
.meas ac ct_a_pf   param='cta*1e12'

.meas ac s_b_fc   find vdb(gb) at=25e6
.meas ac rl_b_fc   param='-s_b_fc'
.meas ac s_b_band  max vdb(gb) from=22.5e6 to=27.5e6
.meas ac rl_b_band param='-s_b_band'
.meas ac s_b_full  max vdb(gb) from=20e6 to=30e6
.meas ac rl_b_full param='-s_b_full'
.meas ac ct_b_pf   param='ctb*1e12'

.meas ac s_c_fc   find vdb(gc) at=25e6
.meas ac rl_c_fc   param='-s_c_fc'
.meas ac s_c_band  max vdb(gc) from=22.5e6 to=27.5e6
.meas ac rl_c_band param='-s_c_band'
.meas ac s_c_full  max vdb(gc) from=20e6 to=30e6
.meas ac rl_c_full param='-s_c_full'
.meas ac ct_c_pf   param='ctc*1e12'

* band-edge points, for the report table
.meas ac s_c_lo find vdb(gc) at=22.5e6
.meas ac rl_c_lo param='-s_c_lo'
.meas ac s_c_hi find vdb(gc) at=27.5e6
.meas ac rl_c_hi param='-s_c_hi'

.end
