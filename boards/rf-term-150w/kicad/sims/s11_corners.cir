* rf-term-150w - BENCH 2: IS THE NULL TWO-SIDED? authority per corner
*
* SOURCE TOPOLOGY / MODEL PROVENANCE / METHOD: identical to s11_band.cir -
* see that file's header for the as-routed CPWG geometry, the residual and
* parasitic audits, and the S11 network trick.
*
* DESIGN INTENT / what this bench proves. The pre-re-route board sat BELOW
* the trimmer's null window: C1 bottomed out at its 1 pF stop in all 12
* builds and had upward-only authority. The re-route was done to fix that.
* This bench decides, as numbers rather than as a claim, whether it did:
*
*  (A) THE AUTHORITY TABLE. For all 48 builds (R x C_port x L) it reports
*      the trimmer contribution the exact null NEEDS, and how far that
*      sits from each stop: down = need - 1 pF, up = 30 pF - need. A
*      POSITIVE down is a real two-sided null; a negative one means C1
*      bottoms out. These are closed-form params, not simulated fits.
*
*  (B) SIMULATED PROOF that the nominal setting is a REAL null and not a
*      clamped mistune: a 1 A AC current probe makes v(z*) = Zin in ohms,
*      so Im{Zin} ~ 0 and Re{Zin} = Reff = R + X^2/R can be read directly.
*
*  (C) TWO-SIDEDNESS DEMONSTRATED, not asserted: at the tightest corner
*      that still has downward authority the bench instantiates C1 BELOW
*      the null, AT the null, and ABOVE it by the same step, and shows the
*      null is strictly the best of the three with both neighbours
*      reachable inside the delivered 1-30 pF range.
*
*  (D) THE COMPOUND WORST CORNER - the honest edge of the design. Under
*      the conservative lump-it-all 6.1 pF convention, at R = 52.5 and the
*      LOW end of the residual band, the null wants LESS trimmer than the
*      1 pF stop can give and C1 bottoms out again. The bench reports how
*      much it misses by and what that costs in return loss.

.param z0=50
.param fc=25e6
.param w0={2*3.141592653589793*fc}
.param cmin=1e-12
.param cmax=30e-12
.param cp47=4.7e-12
.param cp54=5.4e-12
.param cp61=6.1e-12
.param cp65=6.5e-12
.param l185=18.5n
.param l195=19.5n
.param l233=23.3n
.param r49=49.0
.param r50=50.0
.param r51=51.0
.param r525=52.5

* exact susceptance null at fc, and the trimmer setting that realises it,
* clamped to the DELIVERED 1 - 30 pF range of the Johanson 5602
.func copt(rr,ll) {ll/(rr*rr+(w0*ll)*(w0*ll))}
.func ctset(rr,ll,cp) {min(cmax,max(cmin,copt(rr,ll)-cp))}

.subckt oneport p lval=19.5n rval=50 cval=1p cpv=5.4p
Ll p m {lval}
Rt m 0 {rval}
Ct p 0 {cval}
Cp p 0 {cpv}
.ends

Vsrc src 0 AC 2
Vref ref 0 AC 1

* ---- (A) authority table: closed-form params over all 48 builds -----
* (an .ac analysis has to exist for .meas to run at all; the instances
* below serve blocks B-D and this block is pure arithmetic on copt())

* ---- (B) Zin probes: 1 A AC -> v(z) IS Zin in ohms -------------------
Iz1 0 zn AC 1
Xz1 zn oneport lval={l195} rval={r50} cval={ctset(r50,l195,cp54)} cpv={cp54}
Iz2 0 zw AC 1
Xz2 zw oneport lval={l233} rval={r525} cval={ctset(r525,l233,cp47)} cpv={cp47}
Iz3 0 zc AC 1
Xz3 zc oneport lval={l185} rval={r525} cval={ctset(r525,l185,cp61)} cpv={cp61}

* ---- (C) two-sidedness at the tightest corner that still has it ------
* R = 52.5, C_port 5.4 pF, L = 18.5 nH: the null needs 1.2915 pF, i.e.
* only 0.2915 pF of downward authority - the smallest anywhere at the
* nominal parasitic. Three settings: null - 0.2915 (= the 1 pF stop),
* the null itself, and null + 0.2915. Both neighbours are orderable.
.param cnul={ctset(r525,l185,cp54)}
.param cstp=1e-12
.param cup={2*cnul-cstp}
Rsc1 src dc1 {z0}
Xc1 dc1 oneport lval={l185} rval={r525} cval={cstp} cpv={cp54}
Ec1 gc1 0 dc1 ref 1
Rsc2 src dc2 {z0}
Xc2 dc2 oneport lval={l185} rval={r525} cval={cnul} cpv={cp54}
Ec2 gc2 0 dc2 ref 1
Rsc3 src dc3 {z0}
Xc3 dc3 oneport lval={l185} rval={r525} cval={cup} cpv={cp54}
Ec3 gc3 0 dc3 ref 1
* and the same three-point test at the nominal build, where the null has
* 1.3708 pF of downward authority
.param cnun={ctset(r50,l195,cp54)}
.param cupn={2*cnun-cstp}
Rsn1 src dn1 {z0}
Xn1 dn1 oneport lval={l195} rval={r50} cval={cstp} cpv={cp54}
En1 gn1 0 dn1 ref 1
Rsn2 src dn2 {z0}
Xn2 dn2 oneport lval={l195} rval={r50} cval={cnun} cpv={cp54}
En2 gn2 0 dn2 ref 1
Rsn3 src dn3 {z0}
Xn3 dn3 oneport lval={l195} rval={r50} cval={cupn} cpv={cp54}
En3 gn3 0 dn3 ref 1

* ---- (D) the compound worst corner: 6.1 pF lump + R 52.5 + low-L -----
* clamped (what the operator gets) vs the exact null (unbuildable there),
* so the penalty of bottoming out is a subtraction, not an estimate.
Rsd1 src dd1 {z0}
Xd1 dd1 oneport lval={l185} rval={r525} cval={ctset(r525,l185,cp61)} cpv={cp61}
Ed1 gd1 0 dd1 ref 1
Rsd2 src dd2 {z0}
Xd2 dd2 oneport lval={l185} rval={r525} cval={copt(r525,l185)} cpv=1f
Ed2 gd2 0 dd2 ref 1
Rsd3 src dd3 {z0}
Xd3 dd3 oneport lval={l195} rval={r525} cval={ctset(r525,l195,cp61)} cpv={cp61}
Ed3 gd3 0 dd3 ref 1
Rsd4 src dd4 {z0}
Xd4 dd4 oneport lval={l195} rval={r525} cval={copt(r525,l195)} cpv=1f
Ed4 gd4 0 dd4 ref 1
* the deepest clamp anywhere in the sweep: 6.5 pF, R 52.5, 18.5 nH
Rsd5 src dd5 {z0}
Xd5 dd5 oneport lval={l185} rval={r525} cval={ctset(r525,l185,cp65)} cpv={cp65}
Ed5 gd5 0 dd5 ref 1
* and the largest dB penalty anywhere: 6.5 pF, R 50, 18.5 nH (at 55 dB)
Rsd6 src dd6 {z0}
Xd6 dd6 oneport lval={l185} rval={r50} cval={ctset(r50,l185,cp65)} cpv={cp65}
Ed6 gd6 0 dd6 ref 1
Rsd7 src dd7 {z0}
Xd7 dd7 oneport lval={l185} rval={r50} cval={copt(r50,l185)} cpv=1f
Ed7 gd7 0 dd7 ref 1

.ac lin 201 20e6 30e6

* ---- (A) the authority table ----------------------------------------
.meas ac nd_r49_p47_l185 param='(copt(r49,l185)-cp47)*1e12'
.meas ac dn_r49_p47_l185 param='(copt(r49,l185)-cp47-cmin)*1e12'
.meas ac up_r49_p47_l185 param='(cmax-(copt(r49,l185)-cp47))*1e12'
.meas ac nd_r49_p47_l195 param='(copt(r49,l195)-cp47)*1e12'
.meas ac dn_r49_p47_l195 param='(copt(r49,l195)-cp47-cmin)*1e12'
.meas ac up_r49_p47_l195 param='(cmax-(copt(r49,l195)-cp47))*1e12'
.meas ac nd_r49_p47_l233 param='(copt(r49,l233)-cp47)*1e12'
.meas ac dn_r49_p47_l233 param='(copt(r49,l233)-cp47-cmin)*1e12'
.meas ac up_r49_p47_l233 param='(cmax-(copt(r49,l233)-cp47))*1e12'
.meas ac nd_r49_p54_l185 param='(copt(r49,l185)-cp54)*1e12'
.meas ac dn_r49_p54_l185 param='(copt(r49,l185)-cp54-cmin)*1e12'
.meas ac up_r49_p54_l185 param='(cmax-(copt(r49,l185)-cp54))*1e12'
.meas ac nd_r49_p54_l195 param='(copt(r49,l195)-cp54)*1e12'
.meas ac dn_r49_p54_l195 param='(copt(r49,l195)-cp54-cmin)*1e12'
.meas ac up_r49_p54_l195 param='(cmax-(copt(r49,l195)-cp54))*1e12'
.meas ac nd_r49_p54_l233 param='(copt(r49,l233)-cp54)*1e12'
.meas ac dn_r49_p54_l233 param='(copt(r49,l233)-cp54-cmin)*1e12'
.meas ac up_r49_p54_l233 param='(cmax-(copt(r49,l233)-cp54))*1e12'
.meas ac nd_r49_p61_l185 param='(copt(r49,l185)-cp61)*1e12'
.meas ac dn_r49_p61_l185 param='(copt(r49,l185)-cp61-cmin)*1e12'
.meas ac up_r49_p61_l185 param='(cmax-(copt(r49,l185)-cp61))*1e12'
.meas ac nd_r49_p61_l195 param='(copt(r49,l195)-cp61)*1e12'
.meas ac dn_r49_p61_l195 param='(copt(r49,l195)-cp61-cmin)*1e12'
.meas ac up_r49_p61_l195 param='(cmax-(copt(r49,l195)-cp61))*1e12'
.meas ac nd_r49_p61_l233 param='(copt(r49,l233)-cp61)*1e12'
.meas ac dn_r49_p61_l233 param='(copt(r49,l233)-cp61-cmin)*1e12'
.meas ac up_r49_p61_l233 param='(cmax-(copt(r49,l233)-cp61))*1e12'
.meas ac nd_r49_p65_l185 param='(copt(r49,l185)-cp65)*1e12'
.meas ac dn_r49_p65_l185 param='(copt(r49,l185)-cp65-cmin)*1e12'
.meas ac up_r49_p65_l185 param='(cmax-(copt(r49,l185)-cp65))*1e12'
.meas ac nd_r49_p65_l195 param='(copt(r49,l195)-cp65)*1e12'
.meas ac dn_r49_p65_l195 param='(copt(r49,l195)-cp65-cmin)*1e12'
.meas ac up_r49_p65_l195 param='(cmax-(copt(r49,l195)-cp65))*1e12'
.meas ac nd_r49_p65_l233 param='(copt(r49,l233)-cp65)*1e12'
.meas ac dn_r49_p65_l233 param='(copt(r49,l233)-cp65-cmin)*1e12'
.meas ac up_r49_p65_l233 param='(cmax-(copt(r49,l233)-cp65))*1e12'
.meas ac nd_r50_p47_l185 param='(copt(r50,l185)-cp47)*1e12'
.meas ac dn_r50_p47_l185 param='(copt(r50,l185)-cp47-cmin)*1e12'
.meas ac up_r50_p47_l185 param='(cmax-(copt(r50,l185)-cp47))*1e12'
.meas ac nd_r50_p47_l195 param='(copt(r50,l195)-cp47)*1e12'
.meas ac dn_r50_p47_l195 param='(copt(r50,l195)-cp47-cmin)*1e12'
.meas ac up_r50_p47_l195 param='(cmax-(copt(r50,l195)-cp47))*1e12'
.meas ac nd_r50_p47_l233 param='(copt(r50,l233)-cp47)*1e12'
.meas ac dn_r50_p47_l233 param='(copt(r50,l233)-cp47-cmin)*1e12'
.meas ac up_r50_p47_l233 param='(cmax-(copt(r50,l233)-cp47))*1e12'
.meas ac nd_r50_p54_l185 param='(copt(r50,l185)-cp54)*1e12'
.meas ac dn_r50_p54_l185 param='(copt(r50,l185)-cp54-cmin)*1e12'
.meas ac up_r50_p54_l185 param='(cmax-(copt(r50,l185)-cp54))*1e12'
.meas ac nd_r50_p54_l195 param='(copt(r50,l195)-cp54)*1e12'
.meas ac dn_r50_p54_l195 param='(copt(r50,l195)-cp54-cmin)*1e12'
.meas ac up_r50_p54_l195 param='(cmax-(copt(r50,l195)-cp54))*1e12'
.meas ac nd_r50_p54_l233 param='(copt(r50,l233)-cp54)*1e12'
.meas ac dn_r50_p54_l233 param='(copt(r50,l233)-cp54-cmin)*1e12'
.meas ac up_r50_p54_l233 param='(cmax-(copt(r50,l233)-cp54))*1e12'
.meas ac nd_r50_p61_l185 param='(copt(r50,l185)-cp61)*1e12'
.meas ac dn_r50_p61_l185 param='(copt(r50,l185)-cp61-cmin)*1e12'
.meas ac up_r50_p61_l185 param='(cmax-(copt(r50,l185)-cp61))*1e12'
.meas ac nd_r50_p61_l195 param='(copt(r50,l195)-cp61)*1e12'
.meas ac dn_r50_p61_l195 param='(copt(r50,l195)-cp61-cmin)*1e12'
.meas ac up_r50_p61_l195 param='(cmax-(copt(r50,l195)-cp61))*1e12'
.meas ac nd_r50_p61_l233 param='(copt(r50,l233)-cp61)*1e12'
.meas ac dn_r50_p61_l233 param='(copt(r50,l233)-cp61-cmin)*1e12'
.meas ac up_r50_p61_l233 param='(cmax-(copt(r50,l233)-cp61))*1e12'
.meas ac nd_r50_p65_l185 param='(copt(r50,l185)-cp65)*1e12'
.meas ac dn_r50_p65_l185 param='(copt(r50,l185)-cp65-cmin)*1e12'
.meas ac up_r50_p65_l185 param='(cmax-(copt(r50,l185)-cp65))*1e12'
.meas ac nd_r50_p65_l195 param='(copt(r50,l195)-cp65)*1e12'
.meas ac dn_r50_p65_l195 param='(copt(r50,l195)-cp65-cmin)*1e12'
.meas ac up_r50_p65_l195 param='(cmax-(copt(r50,l195)-cp65))*1e12'
.meas ac nd_r50_p65_l233 param='(copt(r50,l233)-cp65)*1e12'
.meas ac dn_r50_p65_l233 param='(copt(r50,l233)-cp65-cmin)*1e12'
.meas ac up_r50_p65_l233 param='(cmax-(copt(r50,l233)-cp65))*1e12'
.meas ac nd_r51_p47_l185 param='(copt(r51,l185)-cp47)*1e12'
.meas ac dn_r51_p47_l185 param='(copt(r51,l185)-cp47-cmin)*1e12'
.meas ac up_r51_p47_l185 param='(cmax-(copt(r51,l185)-cp47))*1e12'
.meas ac nd_r51_p47_l195 param='(copt(r51,l195)-cp47)*1e12'
.meas ac dn_r51_p47_l195 param='(copt(r51,l195)-cp47-cmin)*1e12'
.meas ac up_r51_p47_l195 param='(cmax-(copt(r51,l195)-cp47))*1e12'
.meas ac nd_r51_p47_l233 param='(copt(r51,l233)-cp47)*1e12'
.meas ac dn_r51_p47_l233 param='(copt(r51,l233)-cp47-cmin)*1e12'
.meas ac up_r51_p47_l233 param='(cmax-(copt(r51,l233)-cp47))*1e12'
.meas ac nd_r51_p54_l185 param='(copt(r51,l185)-cp54)*1e12'
.meas ac dn_r51_p54_l185 param='(copt(r51,l185)-cp54-cmin)*1e12'
.meas ac up_r51_p54_l185 param='(cmax-(copt(r51,l185)-cp54))*1e12'
.meas ac nd_r51_p54_l195 param='(copt(r51,l195)-cp54)*1e12'
.meas ac dn_r51_p54_l195 param='(copt(r51,l195)-cp54-cmin)*1e12'
.meas ac up_r51_p54_l195 param='(cmax-(copt(r51,l195)-cp54))*1e12'
.meas ac nd_r51_p54_l233 param='(copt(r51,l233)-cp54)*1e12'
.meas ac dn_r51_p54_l233 param='(copt(r51,l233)-cp54-cmin)*1e12'
.meas ac up_r51_p54_l233 param='(cmax-(copt(r51,l233)-cp54))*1e12'
.meas ac nd_r51_p61_l185 param='(copt(r51,l185)-cp61)*1e12'
.meas ac dn_r51_p61_l185 param='(copt(r51,l185)-cp61-cmin)*1e12'
.meas ac up_r51_p61_l185 param='(cmax-(copt(r51,l185)-cp61))*1e12'
.meas ac nd_r51_p61_l195 param='(copt(r51,l195)-cp61)*1e12'
.meas ac dn_r51_p61_l195 param='(copt(r51,l195)-cp61-cmin)*1e12'
.meas ac up_r51_p61_l195 param='(cmax-(copt(r51,l195)-cp61))*1e12'
.meas ac nd_r51_p61_l233 param='(copt(r51,l233)-cp61)*1e12'
.meas ac dn_r51_p61_l233 param='(copt(r51,l233)-cp61-cmin)*1e12'
.meas ac up_r51_p61_l233 param='(cmax-(copt(r51,l233)-cp61))*1e12'
.meas ac nd_r51_p65_l185 param='(copt(r51,l185)-cp65)*1e12'
.meas ac dn_r51_p65_l185 param='(copt(r51,l185)-cp65-cmin)*1e12'
.meas ac up_r51_p65_l185 param='(cmax-(copt(r51,l185)-cp65))*1e12'
.meas ac nd_r51_p65_l195 param='(copt(r51,l195)-cp65)*1e12'
.meas ac dn_r51_p65_l195 param='(copt(r51,l195)-cp65-cmin)*1e12'
.meas ac up_r51_p65_l195 param='(cmax-(copt(r51,l195)-cp65))*1e12'
.meas ac nd_r51_p65_l233 param='(copt(r51,l233)-cp65)*1e12'
.meas ac dn_r51_p65_l233 param='(copt(r51,l233)-cp65-cmin)*1e12'
.meas ac up_r51_p65_l233 param='(cmax-(copt(r51,l233)-cp65))*1e12'
.meas ac nd_r525_p47_l185 param='(copt(r525,l185)-cp47)*1e12'
.meas ac dn_r525_p47_l185 param='(copt(r525,l185)-cp47-cmin)*1e12'
.meas ac up_r525_p47_l185 param='(cmax-(copt(r525,l185)-cp47))*1e12'
.meas ac nd_r525_p47_l195 param='(copt(r525,l195)-cp47)*1e12'
.meas ac dn_r525_p47_l195 param='(copt(r525,l195)-cp47-cmin)*1e12'
.meas ac up_r525_p47_l195 param='(cmax-(copt(r525,l195)-cp47))*1e12'
.meas ac nd_r525_p47_l233 param='(copt(r525,l233)-cp47)*1e12'
.meas ac dn_r525_p47_l233 param='(copt(r525,l233)-cp47-cmin)*1e12'
.meas ac up_r525_p47_l233 param='(cmax-(copt(r525,l233)-cp47))*1e12'
.meas ac nd_r525_p54_l185 param='(copt(r525,l185)-cp54)*1e12'
.meas ac dn_r525_p54_l185 param='(copt(r525,l185)-cp54-cmin)*1e12'
.meas ac up_r525_p54_l185 param='(cmax-(copt(r525,l185)-cp54))*1e12'
.meas ac nd_r525_p54_l195 param='(copt(r525,l195)-cp54)*1e12'
.meas ac dn_r525_p54_l195 param='(copt(r525,l195)-cp54-cmin)*1e12'
.meas ac up_r525_p54_l195 param='(cmax-(copt(r525,l195)-cp54))*1e12'
.meas ac nd_r525_p54_l233 param='(copt(r525,l233)-cp54)*1e12'
.meas ac dn_r525_p54_l233 param='(copt(r525,l233)-cp54-cmin)*1e12'
.meas ac up_r525_p54_l233 param='(cmax-(copt(r525,l233)-cp54))*1e12'
.meas ac nd_r525_p61_l185 param='(copt(r525,l185)-cp61)*1e12'
.meas ac dn_r525_p61_l185 param='(copt(r525,l185)-cp61-cmin)*1e12'
.meas ac up_r525_p61_l185 param='(cmax-(copt(r525,l185)-cp61))*1e12'
.meas ac nd_r525_p61_l195 param='(copt(r525,l195)-cp61)*1e12'
.meas ac dn_r525_p61_l195 param='(copt(r525,l195)-cp61-cmin)*1e12'
.meas ac up_r525_p61_l195 param='(cmax-(copt(r525,l195)-cp61))*1e12'
.meas ac nd_r525_p61_l233 param='(copt(r525,l233)-cp61)*1e12'
.meas ac dn_r525_p61_l233 param='(copt(r525,l233)-cp61-cmin)*1e12'
.meas ac up_r525_p61_l233 param='(cmax-(copt(r525,l233)-cp61))*1e12'
.meas ac nd_r525_p65_l185 param='(copt(r525,l185)-cp65)*1e12'
.meas ac dn_r525_p65_l185 param='(copt(r525,l185)-cp65-cmin)*1e12'
.meas ac up_r525_p65_l185 param='(cmax-(copt(r525,l185)-cp65))*1e12'
.meas ac nd_r525_p65_l195 param='(copt(r525,l195)-cp65)*1e12'
.meas ac dn_r525_p65_l195 param='(copt(r525,l195)-cp65-cmin)*1e12'
.meas ac up_r525_p65_l195 param='(cmax-(copt(r525,l195)-cp65))*1e12'
.meas ac nd_r525_p65_l233 param='(copt(r525,l233)-cp65)*1e12'
.meas ac dn_r525_p65_l233 param='(copt(r525,l233)-cp65-cmin)*1e12'
.meas ac up_r525_p65_l233 param='(cmax-(copt(r525,l233)-cp65))*1e12'

* ---- (B) Zin probes ---------------------------------------------------
.meas ac rin_nom find vr(zn) at=25e6
.meas ac xin_nom find vi(zn) at=25e6
.meas ac rin_wc find vr(zw) at=25e6
.meas ac xin_wc find vi(zw) at=25e6
.meas ac rin_cl find vr(zc) at=25e6
.meas ac xin_cl find vi(zc) at=25e6

* ---- (C) three-point two-sidedness -----------------------------------
.meas ac s_c_stop find vdb(gc1) at=25e6
.meas ac rl_c_stop param='-s_c_stop'
.meas ac s_c_null find vdb(gc2) at=25e6
.meas ac rl_c_null param='-s_c_null'
.meas ac s_c_up find vdb(gc3) at=25e6
.meas ac rl_c_up param='-s_c_up'
.meas ac d_c_down param='rl_c_null-rl_c_stop'
.meas ac d_c_up param='rl_c_null-rl_c_up'
.meas ac c_null_pf param='cnul*1e12'
.meas ac c_up_pf param='cup*1e12'
.meas ac s_n_stop find vdb(gn1) at=25e6
.meas ac rl_n_stop param='-s_n_stop'
.meas ac s_n_null find vdb(gn2) at=25e6
.meas ac rl_n_null param='-s_n_null'
.meas ac s_n_up find vdb(gn3) at=25e6
.meas ac rl_n_up param='-s_n_up'
.meas ac d_n_down param='rl_n_null-rl_n_stop'
.meas ac d_n_up param='rl_n_null-rl_n_up'
.meas ac n_null_pf param='cnun*1e12'
.meas ac n_up_pf param='cupn*1e12'

* ---- (D) compound worst corner ---------------------------------------
.meas ac s_d1 find vdb(gd1) at=25e6
.meas ac rl_cw_l185 param='-s_d1'
.meas ac s_d2 find vdb(gd2) at=25e6
.meas ac rl_cwid_l185 param='-s_d2'
.meas ac s_d3 find vdb(gd3) at=25e6
.meas ac rl_cw_l195 param='-s_d3'
.meas ac s_d4 find vdb(gd4) at=25e6
.meas ac rl_cwid_l195 param='-s_d4'
.meas ac s_d5 find vdb(gd5) at=25e6
.meas ac rl_cw_p65 param='-s_d5'
.meas ac s_d6 find vdb(gd6) at=25e6
.meas ac rl_pen_r50 param='-s_d6'
.meas ac s_d7 find vdb(gd7) at=25e6
.meas ac rl_penid_r50 param='-s_d7'
.meas ac pen_cw_l185 param='rl_cwid_l185-rl_cw_l185'
.meas ac pen_cw_l195 param='rl_cwid_l195-rl_cw_l195'
.meas ac pen_worst param='rl_penid_r50-rl_pen_r50'
.end
