* rf-term-150w - BENCH 2: 4x4 tolerance corner box at 25.0 MHz
*
* SOURCE TOPOLOGY / MODEL PROVENANCE / METHOD: identical to s11_band.cir - see
* that file's header, including the CORRECTED 2026-08-09 values (C_port 4.7 pF
* not 1.3 pF, review-verify V1; C_trim 1-30 pF Johanson 5602 not 1-35 pF,
* review-verify V2). The whole dynamic board is
*     PORT -+- L_launch - R_term - GND,  +- (C_trim || C_port) - GND.
*
* DESIGN INTENT / what this bench proves. THE WRONG-VALUE CHECK. Every corner
* gets its OWN best trimmer setting - the exact susceptance null at 25.0 MHz,
* clamped to the DELIVERED 1-30 pF range - so what is compared is
* best-achievable RL, never the effect of mistuning. 16 corners:
*   R_term   = 49.0 / 50.0 / 51.0 / 52.5 ohm      rows 1..4
*              49-51 = the select-on-test window (P1 decision), 52.5 = the
*              catalogue +5% limit of T50R0-250-12X
*   L_launch = 5.0 / 7.21 / 15.0 / 30.0 nH        cols a..d
*              7.21 = the AS-ROUTED residual; 5.0 = an optimistic re-route;
*              15.0 and 30.0 = builds with a longer tab lap, thicker or longer
*              ground straps, or a rework - the cases C1 actually exists for.
*
* Two structural facts the sidecar asserts numerically, and they are NOT the
* facts the P2 version of this bench asserted (that version modelled a 1.3 pF
* port and concluded "RL is set by resistance and is blind to inductance"):
*  1. AT THE +5% RESISTANCE CORNER that conclusion still holds. R = 52.5 caps
*     RL at 30.7-31.9 dB across a 6x range of L: dl_r52p5 = -0.20 dB. A shunt
*     susceptance cannot correct Re{Zin} (see reff_limit.cir), so resistance
*     sets the ceiling there and nothing the launch does matters much.
*  2. AT THE NOMINAL RESISTANCE it no longer holds, because the fixed 4.7 pF
*     port capacitance now sets the floor. Every corner below 14.28 nH bottoms
*     the trimmer out (ct_* = 1.000 pF) and is OVER-corrected, so MORE launch
*     inductance IMPROVES the match until the null window is reached:
*     dl_r50p0 = -10.34 dB, i.e. 30 nH beats 5 nH by ten decibels.
*     That inversion is the signature of the corrected parasitic; a bench that
*     reports it the old way around has the port capacitance wrong.
* All 16 corners clear crit. 2 (26 dB) by at least 4.73 dB regardless.

.param z0=50
.param fc=25e6
.param w0={2*3.141592653589793*fc}
.param cpad=4.7e-12
.param cmin=1e-12
.param cmax=30e-12

.func copt(rr,ll) {ll/(rr*rr+(w0*ll)*(w0*ll))}
.func ctset(rr,ll) {min(cmax,max(cmin,copt(rr,ll)-cpad))}

.subckt oneport p lval=7.21n rval=50 cval=1p cpv=4.7p
Ll p m {lval}
Rt m 0 {rval}
Ct p 0 {cval}
Cp p 0 {cpv}
.ends

Vsrc src 0 AC 2
Vref ref 0 AC 1

.param r1=49.0
.param r2=50.0
.param r3=51.0
.param r4=52.5
.param na=5.0n
.param nb=7.21n
.param nc=15.0n
.param nd=30.0n

* --- row 1: R = 49.0 ohm (select-on-test lower limit) --------------------
Rs1a src d1a {z0}
X1a d1a oneport lval={na} rval={r1} cval={ctset(r1,na)} cpv={cpad}
E1a g1a 0 d1a ref 1
Rs1b src d1b {z0}
X1b d1b oneport lval={nb} rval={r1} cval={ctset(r1,nb)} cpv={cpad}
E1b g1b 0 d1b ref 1
Rs1c src d1c {z0}
X1c d1c oneport lval={nc} rval={r1} cval={ctset(r1,nc)} cpv={cpad}
E1c g1c 0 d1c ref 1
Rs1d src d1d {z0}
X1d d1d oneport lval={nd} rval={r1} cval={ctset(r1,nd)} cpv={cpad}
E1d g1d 0 d1d ref 1

* --- row 2: R = 50.0 ohm (nominal) ---------------------------------------
Rs2a src d2a {z0}
X2a d2a oneport lval={na} rval={r2} cval={ctset(r2,na)} cpv={cpad}
E2a g2a 0 d2a ref 1
Rs2b src d2b {z0}
X2b d2b oneport lval={nb} rval={r2} cval={ctset(r2,nb)} cpv={cpad}
E2b g2b 0 d2b ref 1
Rs2c src d2c {z0}
X2c d2c oneport lval={nc} rval={r2} cval={ctset(r2,nc)} cpv={cpad}
E2c g2c 0 d2c ref 1
Rs2d src d2d {z0}
X2d d2d oneport lval={nd} rval={r2} cval={ctset(r2,nd)} cpv={cpad}
E2d g2d 0 d2d ref 1

* --- row 3: R = 51.0 ohm (select-on-test upper limit) --------------------
Rs3a src d3a {z0}
X3a d3a oneport lval={na} rval={r3} cval={ctset(r3,na)} cpv={cpad}
E3a g3a 0 d3a ref 1
Rs3b src d3b {z0}
X3b d3b oneport lval={nb} rval={r3} cval={ctset(r3,nb)} cpv={cpad}
E3b g3b 0 d3b ref 1
Rs3c src d3c {z0}
X3c d3c oneport lval={nc} rval={r3} cval={ctset(r3,nc)} cpv={cpad}
E3c g3c 0 d3c ref 1
Rs3d src d3d {z0}
X3d d3d oneport lval={nd} rval={r3} cval={ctset(r3,nd)} cpv={cpad}
E3d g3d 0 d3d ref 1

* --- row 4: R = 52.5 ohm (catalogue +5% limit) ---------------------------
Rs4a src d4a {z0}
X4a d4a oneport lval={na} rval={r4} cval={ctset(r4,na)} cpv={cpad}
E4a g4a 0 d4a ref 1
Rs4b src d4b {z0}
X4b d4b oneport lval={nb} rval={r4} cval={ctset(r4,nb)} cpv={cpad}
E4b g4b 0 d4b ref 1
Rs4c src d4c {z0}
X4c d4c oneport lval={nc} rval={r4} cval={ctset(r4,nc)} cpv={cpad}
E4c g4c 0 d4c ref 1
Rs4d src d4d {z0}
X4d d4d oneport lval={nd} rval={r4} cval={ctset(r4,nd)} cpv={cpad}
E4d g4d 0 d4d ref 1

.ac lin 201 20e6 30e6

.meas ac s_r49_l5 find vdb(g1a) at=25e6
.meas ac rl_r49_l5 param='-s_r49_l5'
.meas ac ct_r49_l5 param='ctset(r1,na)*1e12'
.meas ac s_r49_l721 find vdb(g1b) at=25e6
.meas ac rl_r49_l721 param='-s_r49_l721'
.meas ac ct_r49_l721 param='ctset(r1,nb)*1e12'
.meas ac s_r49_l15 find vdb(g1c) at=25e6
.meas ac rl_r49_l15 param='-s_r49_l15'
.meas ac ct_r49_l15 param='ctset(r1,nc)*1e12'
.meas ac s_r49_l30 find vdb(g1d) at=25e6
.meas ac rl_r49_l30 param='-s_r49_l30'
.meas ac ct_r49_l30 param='ctset(r1,nd)*1e12'

.meas ac s_r50_l5 find vdb(g2a) at=25e6
.meas ac rl_r50_l5 param='-s_r50_l5'
.meas ac ct_r50_l5 param='ctset(r2,na)*1e12'
.meas ac s_r50_l721 find vdb(g2b) at=25e6
.meas ac rl_r50_l721 param='-s_r50_l721'
.meas ac ct_r50_l721 param='ctset(r2,nb)*1e12'
.meas ac s_r50_l15 find vdb(g2c) at=25e6
.meas ac rl_r50_l15 param='-s_r50_l15'
.meas ac ct_r50_l15 param='ctset(r2,nc)*1e12'
.meas ac s_r50_l30 find vdb(g2d) at=25e6
.meas ac rl_r50_l30 param='-s_r50_l30'
.meas ac ct_r50_l30 param='ctset(r2,nd)*1e12'

.meas ac s_r51_l5 find vdb(g3a) at=25e6
.meas ac rl_r51_l5 param='-s_r51_l5'
.meas ac ct_r51_l5 param='ctset(r3,na)*1e12'
.meas ac s_r51_l721 find vdb(g3b) at=25e6
.meas ac rl_r51_l721 param='-s_r51_l721'
.meas ac ct_r51_l721 param='ctset(r3,nb)*1e12'
.meas ac s_r51_l15 find vdb(g3c) at=25e6
.meas ac rl_r51_l15 param='-s_r51_l15'
.meas ac ct_r51_l15 param='ctset(r3,nc)*1e12'
.meas ac s_r51_l30 find vdb(g3d) at=25e6
.meas ac rl_r51_l30 param='-s_r51_l30'
.meas ac ct_r51_l30 param='ctset(r3,nd)*1e12'

.meas ac s_r525_l5 find vdb(g4a) at=25e6
.meas ac rl_r525_l5 param='-s_r525_l5'
.meas ac ct_r525_l5 param='ctset(r4,na)*1e12'
.meas ac s_r525_l721 find vdb(g4b) at=25e6
.meas ac rl_r525_l721 param='-s_r525_l721'
.meas ac ct_r525_l721 param='ctset(r4,nb)*1e12'
.meas ac s_r525_l15 find vdb(g4c) at=25e6
.meas ac rl_r525_l15 param='-s_r525_l15'
.meas ac ct_r525_l15 param='ctset(r4,nc)*1e12'
.meas ac s_r525_l30 find vdb(g4d) at=25e6
.meas ac rl_r525_l30 param='-s_r525_l30'
.meas ac ct_r525_l30 param='ctset(r4,nd)*1e12'

* --- the wrong-value contrasts, as numbers the sidecar can gate ----------
* dl_* : RL(5.0 nH) - RL(30.0 nH) at fixed R. NEGATIVE at 49-51 ohm: with a
*        fixed 4.7 pF port the low-L corners are over-corrected, so adding
*        inductance improves the match. Nearly zero at 52.5 ohm, where the
*        resistance error dominates everything.
* dr_* : RL(R=50.0) - RL(R=52.5) at fixed L - the resistance penalty.
.meas ac dl_r49 param='rl_r49_l5-rl_r49_l30'
.meas ac dl_r50 param='rl_r50_l5-rl_r50_l30'
.meas ac dl_r51 param='rl_r51_l5-rl_r51_l30'
.meas ac dl_r525 param='rl_r525_l5-rl_r525_l30'
.meas ac dr_l721 param='rl_r50_l721-rl_r525_l721'
.meas ac dr_l15  param='rl_r50_l15-rl_r525_l15'

.end
