* LUM-PAR-A thermal window detector - EMITTER-HOT channel (U401 ch1, out pin 1)
*
* SOURCE NETLIST: work/board.net (kicadsexpr export, P6 routed board).
*   Topology synthesized with
*     sim_run.py --fragment --net work/board.net --refs R405,R406,R407,R408,
*       R416,R410,R401,R403,R413,R415,R409,R411,R412,R414,R207,D401,U401
*   then U401 / RT401 / the off-board emitter NTC (both "unresolved") wired by
*   hand from the fragment pin tables. Every R value below is the netlist
*   value, not a re-typed one.
*
* NET RENAME MAP (simlib.spice_net_name, recorded per the bounds contract):
*   +3V3               -> P3V3            GND                -> 0
*   /FAULT             -> N_FAULT         /NTC_LED           -> N_NTC_LED
*   /thermal/CMP_LED   -> N_THERMAL_CMP_LED
*   /thermal/CMP_BRD   -> N_THERMAL_CMP_BRD
*   /thermal/HYS_LED   -> N_THERMAL_HYS_LED
*   /thermal/HYS_BRD   -> N_THERMAL_HYS_BRD
*   /thermal/LAD_D     -> N_THERMAL_LAD_D
*   /thermal/NTC_BRD   -> N_THERMAL_NTC_BRD
*   /thermal/VREF_EHOT -> N_THERMAL_VREF_EHOT
*   /thermal/VREF_HOT2 -> N_THERMAL_VREF_HOT2
*   /thermal/VREF_OPEN -> N_THERMAL_VREF_OPEN
* Nodes TE / TB / S_* / I_LADDER / HYS_OFF are SIM-ONLY probes (see below).
*
* DESIGN INTENT (architecture/blocks.md B4, requirements PAR-REQ-12):
*   U401 is the board's only fail-safe. Four wire-OR'd open-drain channels
*   assert /FAULT, which gates every output stage through U201. This bench
*   proves the EMITTER-HOT channel trips at 90 C with a POSITIVE hysteresis
*   band - the network was re-derived twice during the build and an earlier
*   revision returned hysteresis to the SENSOR node, which made one channel's
*   band go net-negative (chatter on a progressive crimp failure instead of a
*   clean latch). Solved reference (blocks.md B4 P4 amendment, mated):
*   CMP1 89.9 C trip / 81.2 C release, +8.6 K. The 8.6 K band is knowingly
*   short of the 15 K aspiration - widening it trades against the emitter-OPEN
*   channel's margin and the stop was deliberate. This bench does NOT re-open
*   that; it only proves the band is positive and the trip lands on target.
*
* WHAT IS MODELLED, AND WHAT IS NOT
*   - Dividers are BOTTOM-LEG NTC: +3V3 -> 10 k -> node -> NTC -> GND, so a hot
*     or shorted NTC pulls the sense node DOWN and an open NTC pulls it UP.
*   - Hysteresis returns to the PROTECTED comparator nodes (through R413/R415),
*     never to the sensor dividers. That is the P4 fix under test.
*   - R402/R404 (150 R) + C402/C403 (4.7 uF) feed the carrier's high-Z ADC
*     inputs on J4.19/J4.22. They carry NO DC current and cannot move a
*     threshold, so they are omitted. Verified against the netlist: /ADC0 and
*     /ADC1 have no other loads.
*   - +3V3 is an ideal source. The real rail's regulation is a separate leg.
*   - SPICE's own .temp is left at default and is IRRELEVANT here: the sensor
*     temperature is the sim-only control node TE (1 V == 1 degC), and every
*     resistor in this deck is ideal/tempco-free.
*
* MODEL PROVENANCE (agent-authored generic cards - no vendored vendor files)
*   NTC RT_LED / RT401, HNTC0603-103F3950FB (LCSC C49247666):
*     R(T) = 10k * exp(3950 * (1/T - 1/298.15)), T in kelvin.
*     *** THIS PART PUBLISHES NO DATASHEET. *** parts/parts.json records
*     datasheet:"" and url:"" for it; R25 = 10 k +-1% and B25/50 = 3950 K +-1%
*     from the LCSC parametric record are its ENTIRE specification. A
*     single-beta law fitted between 25 and 50 C is therefore EXTRAPOLATED to
*     90/110/-22 C, and real NTCs deviate from single-beta by a few kelvin out
*     there. Every temperature bound in the sidecar inherits that uncertainty
*     and is widened for it - see the sidecar msgs.
*   U401 LM339LV (LCSC C3658338) - Tier-B BOUNDARY model, never IC internals:
*     decision node S_* = 0.5*(1+tanh((V(IN-)-V(IN+))/200u)), i.e. an ideal
*     comparator smoothed over ~200 uV to emulate finite gain; output is an
*     OPEN-DRAIN SINK ONLY (a conductance to GND, never a source), per
*     parts/C3658338.json "open-drain (sinking-only)". RON = 37.5 ohm from the
*     datasheet VOL point 150 mV typ at ISINK = 4 mA. GOFF = 3.03e-11 S from
*     ILKG 100 pA at VPULLUP = V+ = 3.3 V. Vos (+-3 mV max over temperature)
*     and IB (5 pA) are NOT modelled: IB is negligible against a 10 k series
*     resistor, and Vos is a +-0.4 K threshold shift here, folded into the
*     sidecar windows instead.
*     *** WIRED BY PIN NUMBER, NOT BY CHANNEL NAME. *** parts/C3658338.json
*     records that the datasheet's Figure 5-3 and Table 5.2 transpose the
*     channel 1/2 and 3/4 names (acknowledged in the table's own footnote 1).
*     Pin groupings used here, straight from the netlist:
*       out 1  <- IN- 6  (VREF_EHOT) / IN+ 7  (CMP_LED)   emitter hot
*       out 2  <- IN- 4  (CMP_LED)   / IN+ 5  (VREF_OPEN) emitter open
*       out 14 <- IN- 8  (VREF_HOT2) / IN+ 9  (CMP_BRD)   board hot
*       out 13 <- IN- 10 (VREF_HOT2) / IN+ 11 (CMP_LED)   emitter shorted
*   D401 1N4148W (LCSC C81598): fitted to the datasheet MAX-VF envelope
*     (0.715 V at 1 mA, 0.855 V at 10 mA) -> N = 2.35, IS = 7.8n; RS = 1.0 ohm
*     trims the 50/150 mA points. Fitting the MAX curve is the conservative
*     direction for the clamp check in thermal_fault_inject.cir. D401 is
*     reverse-biased throughout THIS bench and only guards the harness fault.
*
* SWEEP: emitter NTC 40 -> 140 -> 40 C at 1 K/s (TE = 40 + t up-leg). The
* network is purely resistive, so the ramp rate is arbitrary and the run is a
* sequence of quasi-static DC solves. Board NTC held at 40 C so only the
* emitter channels move.
*
* .options rshunt=1e9 is injected by the runner (simlib.prepare_circuit).

* ---------------------------------------------------------------- rail
Vdd P3V3 0 DC 3.3

* ------------------------------------- reference ladder R405-R408 + R416
R405 P3V3 N_THERMAL_VREF_OPEN 2.7k
R406 N_THERMAL_VREF_OPEN N_THERMAL_VREF_EHOT 27k
R407 N_THERMAL_VREF_EHOT N_THERMAL_VREF_HOT2 1.2k
R408 N_THERMAL_VREF_HOT2 N_THERMAL_LAD_D 1.6k
R416 N_THERMAL_LAD_D 0 1.6k

* ------------------- emitter sense divider (NTC is OFF-BOARD, via J5 pin 10)
R403 P3V3 N_NTC_LED 10k
VTE TE 0 PWL(0 40 100 140 200 40)
BRT_LED N_NTC_LED 0 I = v(N_NTC_LED)/(10000*exp(3950*(1/(v(TE)+273.15)-1/298.15)))

* ------------------------------------------- board sense divider (RT401)
R401 P3V3 N_THERMAL_NTC_BRD 10k
VTB TB 0 DC 40
BRT401 N_THERMAL_NTC_BRD 0 I = v(N_THERMAL_NTC_BRD)/(10000*exp(3950*(1/(v(TB)+273.15)-1/298.15)))

* ------------------------------- comparator input protection + rail clamp
R413 N_NTC_LED N_THERMAL_CMP_LED 10k
R415 N_THERMAL_NTC_BRD N_THERMAL_CMP_BRD 10k
D401 N_THERMAL_CMP_LED P3V3 DCLAMP
.model DCLAMP D(IS=7.8n N=2.35 RS=1.0)

* --------------------- hysteresis, returned to the PROTECTED comparator nodes
R409 N_FAULT N_THERMAL_HYS_LED 100k
R411 N_THERMAL_HYS_LED N_THERMAL_CMP_LED 100k
R412 N_FAULT N_THERMAL_HYS_BRD 100k
R414 N_THERMAL_HYS_BRD N_THERMAL_CMP_BRD 100k
R410 N_FAULT N_THERMAL_VREF_OPEN 10k

* ---------------- /FAULT pull-ups: R207 local 100 k || carrier 10 k (MATED)
R207 P3V3 N_FAULT 100k
RCARRIER P3V3 N_FAULT 10k

* -------------------------------------- U401 decision nodes (sim-only probes)
BS_EHOT   S_EHOT   0 V = 0.5*(1+tanh((v(N_THERMAL_VREF_EHOT)-v(N_THERMAL_CMP_LED))/200u))
BS_EOPEN  S_EOPEN  0 V = 0.5*(1+tanh((v(N_THERMAL_CMP_LED)-v(N_THERMAL_VREF_OPEN))/200u))
BS_BHOT   S_BHOT   0 V = 0.5*(1+tanh((v(N_THERMAL_VREF_HOT2)-v(N_THERMAL_CMP_BRD))/200u))
BS_ESHORT S_ESHORT 0 V = 0.5*(1+tanh((v(N_THERMAL_VREF_HOT2)-v(N_THERMAL_CMP_LED))/200u))

* ------------------- U401 open-drain outputs, all four wire-OR'd onto /FAULT
BOUT1  N_FAULT 0 I = v(N_FAULT)*(3.03e-11+(1/37.5-3.03e-11)*v(S_EHOT))
BOUT2  N_FAULT 0 I = v(N_FAULT)*(3.03e-11+(1/37.5-3.03e-11)*v(S_EOPEN))
BOUT14 N_FAULT 0 I = v(N_FAULT)*(3.03e-11+(1/37.5-3.03e-11)*v(S_BHOT))
BOUT13 N_FAULT 0 I = v(N_FAULT)*(3.03e-11+(1/37.5-3.03e-11)*v(S_ESHORT))

* ------------------------------------------- derived probes (sim-only nodes)
* ladder current through R405, in microamps
BILAD I_LADDER 0 V = (v(P3V3)-v(N_THERMAL_VREF_OPEN))/2700*1e6
* hysteresis offset the feedback puts on the protected node, in millivolts
BHOFF HYS_OFF 0 V = (v(N_THERMAL_CMP_LED)-v(N_NTC_LED))*1000
* UNLOADED emitter divider voltage - a pure readout of TE, independent of the
* hysteresis step that jumps the real /NTC_LED node at the snap. This is the
* number the earlier hand solves published as "ladder tap B = 0.2843 V".
BVDIVE V_DIV_E 0 V = 3.3*(10000*exp(3950*(1/(v(TE)+273.15)-1/298.15)))/(10000+10000*exp(3950*(1/(v(TE)+273.15)-1/298.15)))

.tran 0.02 200 0 0.02

* ---- system-level: what /FAULT actually does on a real emitter heat/cool ----
.meas tran ehot_trip_c find v(TE) when v(N_FAULT)=1.65 fall=1
.meas tran ehot_rel_c  find v(TE) when v(N_FAULT)=1.65 rise=1
.meas tran ehot_band_k param='ehot_trip_c-ehot_rel_c'
* ---- per-channel attribution (probe nodes, no circuit loading) ----
.meas tran ch1_trip_c find v(TE) when v(S_EHOT)=0.5 rise=1
.meas tran ch1_rel_c  find v(TE) when v(S_EHOT)=0.5 fall=1
.meas tran ch1_band_k param='ch1_trip_c-ch1_rel_c'
.meas tran ch3_trip_c find v(TE) when v(S_ESHORT)=0.5 rise=1
.meas tran ch3_rel_c  find v(TE) when v(S_ESHORT)=0.5 fall=1
* ---- interface levels on /FAULT (U201 SN74LVC1G08: VIL 0.8 V, VIH 2.0 V) ----
.meas tran fault_voh_v find v(N_FAULT) at=1
.meas tran fault_vol_v find v(N_FAULT) at=60
* ---- quiescent / operating-point facts (no-fault state, 41 C) ----
.meas tran ladder_i_ua  find v(I_LADDER) at=1
.meas tran hys_off_mv   find v(HYS_OFF)  at=1
.meas tran vref_ehot_v  find v(N_THERMAL_VREF_EHOT) at=1
.meas tran vref_hot2_v  find v(N_THERMAL_VREF_HOT2) at=1
.meas tran vref_open_v  find v(N_THERMAL_VREF_OPEN) at=1
* fault-state ladder draw (recorded, not budgeted - R410 sinks into the low
* /FAULT node by design; the 0.10 mA power_tree line is a QUIESCENT budget)
.meas tran ladder_i_fault_ua find v(I_LADDER) at=60
* ---- unloaded-divider equivalent of the emitter-hot trip point ----
.meas tran ehot_trip_div_v find v(V_DIV_E) when v(S_EHOT)=0.5 rise=1
.end
