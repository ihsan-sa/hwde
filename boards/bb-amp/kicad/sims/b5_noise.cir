* bb-amp b5 - integrated noise referred to the input (RTI)
* One lumped RTI voltage-noise density is driven through the real chain and
* integrated by `.meas ac rms`, which ngspice weights by FREQUENCY (verified
* on this host against a closed-form RC integral: 0.124539 measured vs
* 0.124137 analytic). Total rms over [f1,f2] = rms_measure * sqrt(f2-f1).
*
* The injected density is 22.67 nV/rtHz:
*   22.2 nV/rtHz = sqrt(eNI^2 + (eNO/G1)^2) with eNI 22 nV/rtHz and eNO
*     120 nV/rtHz at G1 = 39.9 - the AD8226 Table 3 total-noise FORMULA and
*     its own tabulated densities (the datasheet states no single number).
*   4.59 nV/rtHz = Johnson noise of R1 = RG = 1.27 k at 300 K (4kTR), which
*     sees the full differential gain.
* WHY ONE SOURCE: `.ac` superposes sources COHERENTLY, so two noise sources
* would add as voltages, not in quadrature. Everything else was checked by
* hand and is below 0.5 nV/rtHz RTI and therefore omitted: R4 24.9k ->
* 0.15 nV, R5 10k -> 0.32 nV, the R2/R3 pedestal (9.24 k Thevenin, and C4
* rolls it off at 172 Hz) -> 0.09 nV, both OPA2333 halves (~60 nV/rtHz read
* off SBOS351D Figure 17, divided by G1 = 39.9) -> 1.5 nV.
* NOT MODELLED: 1/f. The OPA2333 is chopper-stabilized and its datasheet
* claims no flicker corner; the AD8226's 0.1-10 Hz spec (0.4 uVpp at
* G >= 100, ~0.06 uVrms) would add about 0.4 % in quadrature to the
* 0.1 Hz - 1 kHz figure below.
*
* ====================== MODELS - agent-authored, GENERIC ======================
* No vendor model file is used anywhere (ai-ee model policy). Every number
* below is a datasheet value taken from the P3 extractions:
*   boards/bb-amp/parts/C34250.json - AD8226ARZ, ADI Rev. C, Table 3 (SINGLE
*                                     supply), Table 8, printed p.19-21
*   boards/bb-amp/parts/C38732.json - OPA2333AIDR, TI SBOS351D, p.3 / p.9
*
* gopamp = generic single-pole op-amp macromodel:
*   1 Tohm differential input -> slew-limited transconductance -> R||C
*   dominant pole (DC gain = aol, unity-gain frequency = gbw) -> anti-windup
*   limiter -> open-loop output resistance ro -> stiff output swing clamp at
*   [vn+vsatlo, vp-vsathi]. Biq draws iq from vp plus what the output SOURCES.
* WHY THE SWING CLAMP SITS AFTER ro AND IS A DIODE PAIR: a datasheet output
*   swing figure is already a LOADED number (OPA2333: 30 mV from the rail at
*   RL = 10 k), so clamping ahead of ro and then dropping ro*Iload on top of
*   it double-counts the loading - measured on the first cut of this model,
*   it put the +25 mV clip at 3.152 V instead of ~3.27 V. The limiter ahead
*   of ro is therefore set 0.4 V BEYOND the rails (it exists only to stop
*   integrator windup) and the real limit is a stiff diode clamp on the
*   output node, which leaves ro free to do its actual job: set the AC output
*   impedance and the capacitive-load stability.
* ANTI-WINDUP CLAMPS THE INTEGRATOR NODE, NOT THE BUFFER. Second measured
*   defect in this model: clamping only the buffer output leaves nint free,
*   and 1 ms of the b4 overload charged it to ~160 V at the slew limit, after
*   which nothing recovered inside the bench. Dawh/Dawl now hold nint itself
*   0.4 V beyond the swing limits, so recovery costs 0.4 V / slew rate.
*   CONSEQUENCE: the overload-RECOVERY TIME this model reports is a property
*   of that 0.4 V headroom, not a datasheet number - neither datasheet states
*   an overload recovery time. What b4 proves structurally is that the output
*   does not invert or fold back; the recovery time is gated as a warning.
* CAPTURES: dc gain, gain-bandwidth, slew rate, output swing limits, output
*   impedance and capacitive-load stability, quiescent + load supply current.
* DOES NOT CAPTURE: input offset voltage and its drift, 1/f noise, the
*   OPA2333 auto-zero chopper, input bias/offset current, PSRR, any
*   temperature coefficient, and - see b2 - the AD8226's real internal-node
*   saturation physics (its Table 8 boundary is HAND-ENTERED as the preamp
*   output clamp, so b2 tests the DESIGN against the datasheet inequality,
*   not the part).
*
.model dclamp D(is=1e-12 n=0.01 rs=0.01 cjo=0)
.subckt gopamp inp inn out vp vn
+ params: gbw=1meg aol=1e6 ro=100 vsathi=0.05 vsatlo=0.05 iq=0 islew=1e6
Rin  inp inn 1T
Bgm  0 nint I = min(max({6.283185307*gbw*1e-6}*(V(inp)-V(inn)), -{islew}), {islew})
Rp   nint 0 {aol/(6.283185307*gbw*1e-6)}
Cp   nint 0 1u
Bhi  nhi 0 V = V(vp)-{vsathi}
Blo  nlo 0 V = V(vn)+{vsatlo}
Bawh nawh 0 V = V(nhi)+0.4
Bawl nawl 0 V = V(nlo)-0.4
Dawh nint nawh dclamp
Dawl nawl nint dclamp
Eo   nbuf 0 nint 0 1
Rout nbuf nsen {ro}
Vsen nsen out 0
Dhi  out nhi dclamp
Dlo  nlo out dclamp
Biq  vp vn I = {iq} + max(i(Vsen), 0)
.ends
*
* AD8226 - classic 3-op-amp in-amp built from its OWN published structure so
* that RG, the internal 50k difference-amp network and the REF pin behave the
* way the datasheet describes. pins: +IN -IN RG RG REF OUT +VS -VS
*   preamp gbw 1.83 MHz: Table 3 tabulates bandwidth only at G = 1/10/100/1000
*     (1500/160/20/2 kHz). No G=39.9 row exists; log-log interpolation between
*     the G=10 and G=100 rows gives 45.8 kHz at G1 = 39.9, so preamp
*     GBW = 45.8 kHz * 39.9 = 1.83 MHz. INTERPOLATED, not a cited figure.
*   preamp clamp [-0.35, +VS-0.70] V: Table 8 at TA = +25 degC
*     (V_MINUS_LIMIT -0.35 V, V_PLUS_LIMIT +0.70 V) - the Equation 1/2
*     internal-node boundary, entered by hand.
*   preamp slew 0.6 V/us: Table 3 slew rate, G = 5 to 100.
*   diff-amp gbw 1.5 MHz / slew 0.4 V/us: Table 3 G = 1 rows.
*   diff-amp clamp [0.1, +VS-0.1] V: Table 3 OUTPUT, Output Swing,
*     RL = 10 kohm, TA = -40 to +125 degC.
*   Iq 325 uA: Table 3 quiescent current, 25 degC typ (400 uA max).
*   Ecm: Table 3 CMRR (DC to 60 Hz) is 106 dB min at G=10 and 120 dB min at
*     G=100; there is no G=39.9 row, so the CONSERVATIVE G=10 minimum
*     (106 dB = 5.012e-6 V/V) is injected as a common-mode-to-differential
*     error in series with +IN. Model offset voltage is ZERO: the datasheet
*     gives only maxima (VOSI 100 uV, VOSO 600 uV -> 115 uV RTI -> 16 mV at
*     the board output) and requirements Q7 calibrates initial offset out.
.subckt ad8226 inp inn rga rgb ref out vp vn
Rcm1 inp ncm 10meg
Rcm2 inn ncm 10meg
Ecm  nipe inp ncm 0 5.012e-6
XA1  nipe rga nd1 vp vn gopamp gbw=1.83meg aol=1e6 ro=100 vsathi=0.70 vsatlo=-0.35 islew=0.6
RF1  nd1 rga 24.7k
XA2  inn  rgb nd2 vp vn gopamp gbw=1.83meg aol=1e6 ro=100 vsathi=0.70 vsatlo=-0.35 islew=0.6
RF2  nd2 rgb 24.7k
R11  nd2 na3n 50k
R12  na3n out 50k
R21  nd1 na3p 50k
R22  na3p ref 50k
XA3  na3p na3n out vp vn gopamp gbw=1.5meg aol=1e6 ro=100 vsathi=0.10 vsatlo=0.10 islew=0.4
Iq   vp vn 325u
.ends
*
* The bb-amp signal chain exactly as the board is built.
* pins: IN+ IN- OUT +3V3 GND.  params: cl / rl = the J2 load, ro2333 = the
* OPA2333 open-loop output resistance (see the b10/b11 headers for why it is
* bracketed), riso = an OPTIONAL series isolation resistor between U2B's
* output and J2.
* THE SHIPPING BOARD FITS NO ISOLATION RESISTOR. R6 = 100 R existed at P3 and
* was REMOVED at P4 on the evidence of b11: the OPA2333 Figure 15 overshoot
* curve that motivated it is a UNITY-GAIN measurement, and U2B runs at a
* noise gain of 3.49, where the same calibrated model gives 6.6 % overshoot
* into the full 1 nF with no isolation resistor at all. At `block-only`
* scope, conditioning the datasheet does not require is out of scope, so an
* unnecessary part must not ship. riso = 0.001 ohm IS the shipping circuit (a
* 1 milliohm stand-in for the direct wire, so the element still has a name);
* b10 and b11 sweep riso only to keep the evidence for the removal
* reproducible, and gate ONLY the riso = 0.001 case. This also restores
* blocks.md B5, which had rejected any series output resistor. OPA2333: GBW 350 kHz typ, AOL 130 dB typ (106 dB min) -> 3.16e6,
* output swing 30 mV typ from either rail (RL = 10k, 25 degC; 50 mV max),
* slew 0.16 V/us, IQ 17 uA/channel typ - all TI SBOS351D p.3.
.subckt chain nip nin nout p3v3 gnd
+ params: riso=0.001 cl=1p rl=100k ro2333=1k
XU1  nip nin n_rga n_rgb n_vref n_amp1 p3v3 gnd ad8226
R1   n_rga n_rgb 1.27k
R2   p3v3 n_vrefset 121k
R3   n_vrefset gnd 10k
C4   n_vrefset gnd 100n
XU2A n_vrefset n_vref n_vref p3v3 gnd gopamp gbw=350k aol=3.16e6 ro={ro2333}
+    vsathi=0.030 vsatlo=0.030 iq=17u islew=0.16
XU2B n_amp1 n_fb n_u2bout p3v3 gnd gopamp gbw=350k aol=3.16e6 ro={ro2333}
+    vsathi=0.030 vsatlo=0.030 iq=17u islew=0.16
R4   n_u2bout n_fb 24.9k
R5   n_fb n_vref 10k
RISO n_u2bout nout {riso}
C1   p3v3 gnd 100n
C2   p3v3 gnd 10u
C3   p3v3 gnd 100n
CL   nout gnd {cl}
RL   nout gnd {rl}
.ends
*
* NETLIST CROSS-CHECK (2026-08-16, P4; RE-TAKEN after the R6 removal). These benches were TYPED from
* architecture/blocks.md s1-s2 and constraints.json, not synthesized, because
* schematic-block was authoring the sheet concurrently. As soon as
* kicad/bb-amp.net appeared it was diffed against them with
*   sim_run.py --fragment --net kicad/bb-amp.net --refs R1,R2,R3,R4,R5
* and every value and every connection MATCHES what is modelled here:
*   R1 1.27k across U1 pins 2-3 (/RG_A,/RG_B)  R2 121k  +3V3 -> /VREF_SET
*   R3 10.0k /VREF_SET -> GND                  C4 100n on /VREF_SET
*   R4 24.9k /VOUT -> /FB2                     R5 10.0k /FB2 -> /VREF
*   C1,C3 100n / C2 10u on +3V3                NO R6 - `--refs R6` now
*     answers "refs not in netlist", U2B pin 7 IS /VOUT and drives J2 pin 1
*     directly, and the net /AMP2_OUT no longer exists (R6 removed at P4 by
*     ruling on b11's evidence - see the chain subckt and the b10/b11 heads)
*   U1 REF (pin 6) = /VREF - the BUFFERED node, not the divider, not ground
*   U2A = unity buffer: OUTA = INA- = /VREF, INA+ = /VREF_SET
*   U2B: INB+ = /AMP1_OUT, INB- = /FB2, OUTB = /AMP2_OUT
*   and R5 returns to /VREF, NOT to ground - the one wire blocks.md s2 turns
*   on, and the one a netlist diff is the only way to confirm.
* Net map, bench -> schematic: n_ip=/IN_P n_in=/IN_N n_rga=/RG_A n_rgb=/RG_B
* n_amp1=/AMP1_OUT n_vrefset=/VREF_SET n_vref=/VREF n_fb=/FB2
* n_u2bout and n_out are BOTH /VOUT on the shipping board (they are the two
* ends of the 1 milliohm riso stand-in); p3v3=+3V3 gnd=GND.
* THE CROSS-CHECK IS A SNAPSHOT: these benches carry their own copy of every
* value and will NOT notice a later schematic edit. Re-run the --fragment
* diff above after any change to R1..R5, R2/R3 or the U2 pin assignment.
*
* Sensor source: 350 ohm bridge (requirements Q3) split 175/175, common mode
* pinned at 1.65 V (Q1). V(nd) IS the differential input in volts.
*
* SWEEP PADDING (engine fact, measured on this host, ngspice 46): the FIRST
* point of a .dc sweep is solved from scratch and this 5-op-amp chain can
* land there on a junk operating point (gmin AND source stepping both report
* failure), while `at=` on the LAST point returns 'out of interval'. Every
* .dc and .ac range below is therefore padded so that no measured point is a
* sweep endpoint. Second and later points converge from the previous
* solution and are correct.

.temp 25
VS   p3v3 0 DC 3.3
Vcm  n_cm 0 DC 1.65
Vd   n_d  0 DC 0.010 AC 22.67e-9
Ep   n_sp n_cm n_d 0 0.5
En   n_sn n_cm n_d 0 -0.5
Rsp  n_sp n_ip 175
Rsn  n_sn n_in 175
X1   n_ip n_in n_out p3v3 0 chain riso=0.001 cl=1p rl=100k ro2333=1k
.ac lin 30000 0.05 41100
.meas ac nd_dc    find vm(n_out) at=0.1
.meas ac nd_1k    find vm(n_out) at=1000
.meas ac nrms_1k  rms vm(n_out) from=0.1 to=1000
.meas ac nrms_41k rms vm(n_out) from=0.1 to=41000
.meas ac gdc_vv   param='nd_dc/22.67e-9'
.meas ac rti_1k_uv  param='nrms_1k*sqrt(999.9)/gdc_vv*1e6'
.meas ac rti_41k_uv param='nrms_41k*sqrt(40999.9)/gdc_vv*1e6'
.meas ac rti_dens_nv param='nd_dc/gdc_vv*1e9'
.end
