* bb-amp b10 - what value does R6 have to be? (the P3 provisional 100 R)
* R6 was added at P3, after blocks.md was written, because OPA2333 Figure 15
* shows small-signal overshoot climbing to roughly the mid-30 % range by
* CL = 1 nF and requirements Q8 allows up to 1 nF of output cable. Its value
* was left PROVISIONAL for this bench to settle.
* ngspice has no `.step`, so R6 is swept by REPLICATING the whole chain: six
* R6 values x two OPA2333 open-loop output resistances, all driven by ONE
* input step, plus two CL = 1 pF controls.
*   a1..a6: ro = 1.0 kohm - calibrated so the same macromodel in UNITY gain
*     reproduces Figure 15's ~35 % overshoot at CL = 1 nF.
*   b1..b6: ro = 2.0 kohm - TI's literal open-loop figure (stated only at
*     f = 350 kHz), carried as the pessimistic bracket.
*   R6 = 0.001 ohm stands in for R6 absent (a 0 ohm resistor is legal in
*     ngspice but makes the node a short with no element to name).
* os_* is percent overshoot of the 0 -> 20 mV full-scale step measured AT J2,
* which is what the cable and the reader actually see. sp_* is the delivered
* span as a percentage of the unloaded 2.78480 V design span - i.e. what the
* R6/RL divider costs, the objection blocks.md B5 raised against any series
* resistor (requirements Q8 guarantees RL > 100 k).
*
* ====================== MODELS - agent-authored, GENERIC ======================
* No vendor model file is used anywhere (ai-ee model policy). Every number
* below is a datasheet value taken from the P3 extractions:
*   boards/bb-amp/parts/C34250.json - AD8226ARZ, ADI Rev. C, Table 3 (SINGLE
*                                     supply), Table 8, printed p.19-21
*   boards/bb-amp/parts/C38732.json - OPA2333AIDR, TI SBOS351D, p.3 / p.9
*
* gopamp = generic single-pole op-amp macromodel:
*   1 Tohm differential input -> slew-limited transconductance -> R||C
*   dominant pole (DC gain = aol, unity-gain frequency = gbw) -> anti-windup
*   limiter -> open-loop output resistance ro -> stiff output swing clamp at
*   [vn+vsatlo, vp-vsathi]. Biq draws iq from vp plus what the output SOURCES.
* WHY THE SWING CLAMP SITS AFTER ro AND IS A DIODE PAIR: a datasheet output
*   swing figure is already a LOADED number (OPA2333: 30 mV from the rail at
*   RL = 10 k), so clamping ahead of ro and then dropping ro*Iload on top of
*   it double-counts the loading - measured on the first cut of this model,
*   it put the +25 mV clip at 3.152 V instead of ~3.27 V. The limiter ahead
*   of ro is therefore set 0.4 V BEYOND the rails (it exists only to stop
*   integrator windup) and the real limit is a stiff diode clamp on the
*   output node, which leaves ro free to do its actual job: set the AC output
*   impedance and the capacitive-load stability.
* CAPTURES: dc gain, gain-bandwidth, slew rate, output swing limits, output
*   impedance and capacitive-load stability, quiescent + load supply current.
* DOES NOT CAPTURE: input offset voltage and its drift, 1/f noise, the
*   OPA2333 auto-zero chopper, input bias/offset current, PSRR, any
*   temperature coefficient, and - see b2 - the AD8226's real internal-node
*   saturation physics (its Table 8 boundary is HAND-ENTERED as the preamp
*   output clamp, so b2 tests the DESIGN against the datasheet inequality,
*   not the part).
*
.model dclamp D(is=1e-12 n=0.02 rs=0.01 cjo=0)
.subckt gopamp inp inn out vp vn
+ params: gbw=1meg aol=1e6 ro=100 vsathi=0.05 vsatlo=0.05 iq=0 islew=1e6
Rin  inp inn 1T
Bgm  0 nint I = min(max({6.283185307*gbw*1e-6}*(V(inp)-V(inn)), -{islew}), {islew})
Rp   nint 0 {aol/(6.283185307*gbw*1e-6)}
Cp   nint 0 1u
Bhi  nhi 0 V = V(vp)-{vsathi}
Blo  nlo 0 V = V(vn)+{vsatlo}
Bo   nbuf 0 V = min(max(V(nint), V(nlo)-0.4), max(V(nhi)+0.4, V(nlo)-0.4+1e-6))
Rout nbuf nsen {ro}
Vsen nsen out 0
Dhi  out nhi dclamp
Dlo  nlo out dclamp
Biq  vp vn I = {iq} + max(i(Vsen), 0)
.ends
*
* AD8226 - classic 3-op-amp in-amp built from its OWN published structure so
* that RG, the internal 50k difference-amp network and the REF pin behave the
* way the datasheet describes. pins: +IN -IN RG RG REF OUT +VS -VS
*   preamp gbw 1.83 MHz: Table 3 tabulates bandwidth only at G = 1/10/100/1000
*     (1500/160/20/2 kHz). No G=39.9 row exists; log-log interpolation between
*     the G=10 and G=100 rows gives 45.8 kHz at G1 = 39.9, so preamp
*     GBW = 45.8 kHz * 39.9 = 1.83 MHz. INTERPOLATED, not a cited figure.
*   preamp clamp [-0.35, +VS-0.70] V: Table 8 at TA = +25 degC
*     (V_MINUS_LIMIT -0.35 V, V_PLUS_LIMIT +0.70 V) - the Equation 1/2
*     internal-node boundary, entered by hand.
*   preamp slew 0.6 V/us: Table 3 slew rate, G = 5 to 100.
*   diff-amp gbw 1.5 MHz / slew 0.4 V/us: Table 3 G = 1 rows.
*   diff-amp clamp [0.1, +VS-0.1] V: Table 3 OUTPUT, Output Swing,
*     RL = 10 kohm, TA = -40 to +125 degC.
*   Iq 325 uA: Table 3 quiescent current, 25 degC typ (400 uA max).
*   Ecm: Table 3 CMRR (DC to 60 Hz) is 106 dB min at G=10 and 120 dB min at
*     G=100; there is no G=39.9 row, so the CONSERVATIVE G=10 minimum
*     (106 dB = 5.012e-6 V/V) is injected as a common-mode-to-differential
*     error in series with +IN. Model offset voltage is ZERO: the datasheet
*     gives only maxima (VOSI 100 uV, VOSO 600 uV -> 115 uV RTI -> 16 mV at
*     the board output) and requirements Q7 calibrates initial offset out.
.subckt ad8226 inp inn rga rgb ref out vp vn
Rcm1 inp ncm 10meg
Rcm2 inn ncm 10meg
Ecm  nipe inp ncm 0 5.012e-6
XA1  nipe rga nd1 vp vn gopamp gbw=1.83meg aol=1e6 ro=100 vsathi=0.70 vsatlo=-0.35 islew=0.6
RF1  nd1 rga 24.7k
XA2  inn  rgb nd2 vp vn gopamp gbw=1.83meg aol=1e6 ro=100 vsathi=0.70 vsatlo=-0.35 islew=0.6
RF2  nd2 rgb 24.7k
R11  nd2 na3n 50k
R12  na3n out 50k
R21  nd1 na3p 50k
R22  na3p ref 50k
XA3  na3p na3n out vp vn gopamp gbw=1.5meg aol=1e6 ro=100 vsathi=0.10 vsatlo=0.10 islew=0.4
Iq   vp vn 325u
.ends
*
* The bb-amp signal chain exactly as architecture/blocks.md specifies it.
* pins: IN+ IN- OUT +3V3 GND.  params: r6 / cl / rl = the J2 load, ro2333 =
* the OPA2333 open-loop output resistance (see the b10 header for why it is
* swept). OPA2333: GBW 350 kHz typ, AOL 130 dB typ (106 dB min) -> 3.16e6,
* output swing 30 mV typ from either rail (RL = 10k, 25 degC; 50 mV max),
* slew 0.16 V/us, IQ 17 uA/channel typ - all TI SBOS351D p.3.
.subckt chain nip nin nout p3v3 gnd
+ params: r6=100 cl=1p rl=100k ro2333=1k
XU1  nip nin n_rga n_rgb n_vref n_amp1 p3v3 gnd ad8226
R1   n_rga n_rgb 1.27k
R2   p3v3 n_vrefset 121k
R3   n_vrefset gnd 10k
C4   n_vrefset gnd 100n
XU2A n_vrefset n_vref n_vref p3v3 gnd gopamp gbw=350k aol=3.16e6 ro={ro2333}
+    vsathi=0.030 vsatlo=0.030 iq=17u islew=0.16
XU2B n_amp1 n_fb n_u2bout p3v3 gnd gopamp gbw=350k aol=3.16e6 ro={ro2333}
+    vsathi=0.030 vsatlo=0.030 iq=17u islew=0.16
R4   n_u2bout n_fb 24.9k
R5   n_fb n_vref 10k
R6   n_u2bout nout {r6}
C1   p3v3 gnd 100n
C2   p3v3 gnd 10u
C3   p3v3 gnd 100n
CL   nout gnd {cl}
RL   nout gnd {rl}
.ends
*
* Sensor source: 350 ohm bridge (requirements Q3) split 175/175, common mode
* pinned at 1.65 V (Q1). V(nd) IS the differential input in volts.
*
* SWEEP PADDING (engine fact, measured on this host, ngspice 46): the FIRST
* point of a .dc sweep is solved from scratch and this 5-op-amp chain can
* land there on a junk operating point (gmin AND source stepping both report
* failure), while `at=` on the LAST point returns 'out of interval'. Every
* .dc and .ac range below is therefore padded so that no measured point is a
* sweep endpoint. Second and later points converge from the previous
* solution and are correct.

.temp 25
VS   p3v3 0 DC 3.3
Vcm  n_cm 0 DC 1.65
Vd   n_d  0 PWL(0 0 100u 0 101u 0.020 500u 0.020)
Ep   n_sp n_cm n_d 0 0.5
En   n_sn n_cm n_d 0 -0.5
Rsp  n_sp n_ip 175
Rsn  n_sn n_in 175
Xa1  n_ip n_in oa1 p3v3 0 chain r6=0.001 cl=1n rl=100k ro2333=1k
Xa2  n_ip n_in oa2 p3v3 0 chain r6=47 cl=1n rl=100k ro2333=1k
Xa3  n_ip n_in oa3 p3v3 0 chain r6=100 cl=1n rl=100k ro2333=1k
Xa4  n_ip n_in oa4 p3v3 0 chain r6=220 cl=1n rl=100k ro2333=1k
Xa5  n_ip n_in oa5 p3v3 0 chain r6=470 cl=1n rl=100k ro2333=1k
Xa6  n_ip n_in oa6 p3v3 0 chain r6=1000 cl=1n rl=100k ro2333=1k
Xb1  n_ip n_in ob1 p3v3 0 chain r6=0.001 cl=1n rl=100k ro2333=2k
Xb2  n_ip n_in ob2 p3v3 0 chain r6=47 cl=1n rl=100k ro2333=2k
Xb3  n_ip n_in ob3 p3v3 0 chain r6=100 cl=1n rl=100k ro2333=2k
Xb4  n_ip n_in ob4 p3v3 0 chain r6=220 cl=1n rl=100k ro2333=2k
Xb5  n_ip n_in ob5 p3v3 0 chain r6=470 cl=1n rl=100k ro2333=2k
Xb6  n_ip n_in ob6 p3v3 0 chain r6=1000 cl=1n rl=100k ro2333=2k
Xc1  n_ip n_in oc1 p3v3 0 chain r6=100 cl=1p rl=100k ro2333=1k
Xc2  n_ip n_in oc2 p3v3 0 chain r6=100 cl=1p rl=100k ro2333=2k
.tran 20n 500u
.meas tran lo_a1 find v(oa1) at=99u
.meas tran fs_a1 find v(oa1) at=450u
.meas tran pk_a1 max  v(oa1) from=100u to=350u
.meas tran os_a1 param='(pk_a1-fs_a1)/(fs_a1-lo_a1)*100'
.meas tran lo_a2 find v(oa2) at=99u
.meas tran fs_a2 find v(oa2) at=450u
.meas tran pk_a2 max  v(oa2) from=100u to=350u
.meas tran os_a2 param='(pk_a2-fs_a2)/(fs_a2-lo_a2)*100'
.meas tran lo_a3 find v(oa3) at=99u
.meas tran fs_a3 find v(oa3) at=450u
.meas tran pk_a3 max  v(oa3) from=100u to=350u
.meas tran os_a3 param='(pk_a3-fs_a3)/(fs_a3-lo_a3)*100'
.meas tran lo_a4 find v(oa4) at=99u
.meas tran fs_a4 find v(oa4) at=450u
.meas tran pk_a4 max  v(oa4) from=100u to=350u
.meas tran os_a4 param='(pk_a4-fs_a4)/(fs_a4-lo_a4)*100'
.meas tran lo_a5 find v(oa5) at=99u
.meas tran fs_a5 find v(oa5) at=450u
.meas tran pk_a5 max  v(oa5) from=100u to=350u
.meas tran os_a5 param='(pk_a5-fs_a5)/(fs_a5-lo_a5)*100'
.meas tran lo_a6 find v(oa6) at=99u
.meas tran fs_a6 find v(oa6) at=450u
.meas tran pk_a6 max  v(oa6) from=100u to=350u
.meas tran os_a6 param='(pk_a6-fs_a6)/(fs_a6-lo_a6)*100'
.meas tran lo_b1 find v(ob1) at=99u
.meas tran fs_b1 find v(ob1) at=450u
.meas tran pk_b1 max  v(ob1) from=100u to=350u
.meas tran os_b1 param='(pk_b1-fs_b1)/(fs_b1-lo_b1)*100'
.meas tran lo_b2 find v(ob2) at=99u
.meas tran fs_b2 find v(ob2) at=450u
.meas tran pk_b2 max  v(ob2) from=100u to=350u
.meas tran os_b2 param='(pk_b2-fs_b2)/(fs_b2-lo_b2)*100'
.meas tran lo_b3 find v(ob3) at=99u
.meas tran fs_b3 find v(ob3) at=450u
.meas tran pk_b3 max  v(ob3) from=100u to=350u
.meas tran os_b3 param='(pk_b3-fs_b3)/(fs_b3-lo_b3)*100'
.meas tran lo_b4 find v(ob4) at=99u
.meas tran fs_b4 find v(ob4) at=450u
.meas tran pk_b4 max  v(ob4) from=100u to=350u
.meas tran os_b4 param='(pk_b4-fs_b4)/(fs_b4-lo_b4)*100'
.meas tran lo_b5 find v(ob5) at=99u
.meas tran fs_b5 find v(ob5) at=450u
.meas tran pk_b5 max  v(ob5) from=100u to=350u
.meas tran os_b5 param='(pk_b5-fs_b5)/(fs_b5-lo_b5)*100'
.meas tran lo_b6 find v(ob6) at=99u
.meas tran fs_b6 find v(ob6) at=450u
.meas tran pk_b6 max  v(ob6) from=100u to=350u
.meas tran os_b6 param='(pk_b6-fs_b6)/(fs_b6-lo_b6)*100'
.meas tran lo_c1 find v(oc1) at=99u
.meas tran fs_c1 find v(oc1) at=450u
.meas tran pk_c1 max  v(oc1) from=100u to=350u
.meas tran os_c1 param='(pk_c1-fs_c1)/(fs_c1-lo_c1)*100'
.meas tran lo_c2 find v(oc2) at=99u
.meas tran fs_c2 find v(oc2) at=450u
.meas tran pk_c2 max  v(oc2) from=100u to=350u
.meas tran os_c2 param='(pk_c2-fs_c2)/(fs_c2-lo_c2)*100'
.meas tran sp_a1 param='(fs_a1-lo_a1)/2.78480*100'
.meas tran sp_a2 param='(fs_a2-lo_a2)/2.78480*100'
.meas tran sp_a3 param='(fs_a3-lo_a3)/2.78480*100'
.meas tran sp_a4 param='(fs_a4-lo_a4)/2.78480*100'
.meas tran sp_a5 param='(fs_a5-lo_a5)/2.78480*100'
.meas tran sp_a6 param='(fs_a6-lo_a6)/2.78480*100'
.meas tran sp_b1 param='(fs_b1-lo_b1)/2.78480*100'
.meas tran sp_b2 param='(fs_b2-lo_b2)/2.78480*100'
.meas tran sp_b3 param='(fs_b3-lo_b3)/2.78480*100'
.meas tran sp_b4 param='(fs_b4-lo_b4)/2.78480*100'
.meas tran sp_b5 param='(fs_b5-lo_b5)/2.78480*100'
.meas tran sp_b6 param='(fs_b6-lo_b6)/2.78480*100'
.meas tran sp_c1 param='(fs_c1-lo_c1)/2.78480*100'
.meas tran sp_c2 param='(fs_c2-lo_c2)/2.78480*100'
.end
