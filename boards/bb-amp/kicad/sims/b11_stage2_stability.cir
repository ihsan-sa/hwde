* bb-amp b11 - SMALL-SIGNAL stability of the output stage into the cable
* b10 drives the whole chain and finds almost no ringing, because U1's
* 45.8 kHz pole and the OPA2333's 0.16 V/us slew rate between them turn a
* full-scale 20 mV input step into a ~17 us edge that cannot excite a ~100
* kHz loop. That is the OPERATIONAL answer; it is not a stability margin.
* This bench asks the stability question directly, the way OPA2333 Figure 15
* asks it: a SMALL step (20 mV at the stage input -> ~70 mV out, needing
* about 0.014 V/us, well under the slew limit) applied to the output stage
* on its own.
*
* ub1..ub4 are the CALIBRATION, and they are here to be audited: a PLAIN
* unity-gain OPA2333 follower with CL straight on the pin, at CL = 100 pF and
* 1 nF, for ro = 1 kohm and 2 kohm. Figure 15 (SBOS351D p.9 - a graph read;
* the datasheet tabulates no capacitive-load number at all) shows overshoot
* around 0-5 % out to 100-200 pF and roughly the mid-30 % range by 1 nF.
* ro = 1.0 kohm is chosen to reproduce that. ro = 2 kohm is TI's own literal
* open-loop output impedance, which it states ONLY at f = 350 kHz, carried
* here as the pessimistic bracket. Whichever bracket the reader believes, the
* R6 answer is read off the same table.
*
* s_r* / t_r* are the ACTUAL U2B stage - G2 = 3.49, R4 24.9 k, R5 10 k
* returned to a fixed 0.2519 V pedestal - into CL = 1 nF (requirements Q8
* worst case), with riso = 0 / 47 / 100 / 220 / 470 / 1000 ohm. s_nc, t_nc
* are the CL = 1 pF controls. U2B is NOT a unity-gain follower: its noise
* gain of 3.49 puts the loop crossover at 350 kHz / 3.49 = 100 kHz instead of
* 350 kHz, and that is worth roughly 25 degrees of phase margin against the
* same 1 nF. THAT is the finding that removed R6, and s_r0 / t_r0 - the
* shipping circuit, no isolation resistor - are what this bench GATES. The
* riso = 47 .. 1000 ohm instances stay UNGATED as reproducible evidence: they
* are what an isolation resistor would have bought, and they show that the
* fitted 100 R bought 0.3 to 1.3 points of it because an out-of-loop series R
* has authority only in proportion to riso/ro.
*
* ====================== MODELS - agent-authored, GENERIC ======================
* No vendor model file is used anywhere (ai-ee model policy). Every number
* below is a datasheet value taken from the P3 extractions:
*   boards/bb-amp/parts/C34250.json - AD8226ARZ, ADI Rev. C, Table 3 (SINGLE
*                                     supply), Table 8, printed p.19-21
*   boards/bb-amp/parts/C38732.json - OPA2333AIDR, TI SBOS351D, p.3 / p.9
*
* gopamp = generic single-pole op-amp macromodel:
*   1 Tohm differential input -> slew-limited transconductance -> R||C
*   dominant pole (DC gain = aol, unity-gain frequency = gbw) -> anti-windup
*   limiter -> open-loop output resistance ro -> stiff output swing clamp at
*   [vn+vsatlo, vp-vsathi]. Biq draws iq from vp plus what the output SOURCES.
* WHY THE SWING CLAMP SITS AFTER ro AND IS A DIODE PAIR: a datasheet output
*   swing figure is already a LOADED number (OPA2333: 30 mV from the rail at
*   RL = 10 k), so clamping ahead of ro and then dropping ro*Iload on top of
*   it double-counts the loading - measured on the first cut of this model,
*   it put the +25 mV clip at 3.152 V instead of ~3.27 V. The limiter ahead
*   of ro is therefore set 0.4 V BEYOND the rails (it exists only to stop
*   integrator windup) and the real limit is a stiff diode clamp on the
*   output node, which leaves ro free to do its actual job: set the AC output
*   impedance and the capacitive-load stability.
* ANTI-WINDUP CLAMPS THE INTEGRATOR NODE, NOT THE BUFFER. Second measured
*   defect in this model: clamping only the buffer output leaves nint free,
*   and 1 ms of the b4 overload charged it to ~160 V at the slew limit, after
*   which nothing recovered inside the bench. Dawh/Dawl now hold nint itself
*   0.4 V beyond the swing limits, so recovery costs 0.4 V / slew rate.
*   CONSEQUENCE: the overload-RECOVERY TIME this model reports is a property
*   of that 0.4 V headroom, not a datasheet number - neither datasheet states
*   an overload recovery time. What b4 proves structurally is that the output
*   does not invert or fold back; the recovery time is gated as a warning.
* CAPTURES: dc gain, gain-bandwidth, slew rate, output swing limits, output
*   impedance and capacitive-load stability, quiescent + load supply current.
* DOES NOT CAPTURE: input offset voltage and its drift, 1/f noise, the
*   OPA2333 auto-zero chopper, input bias/offset current, PSRR, any
*   temperature coefficient, and - see b2 - the AD8226's real internal-node
*   saturation physics (its Table 8 boundary is HAND-ENTERED as the preamp
*   output clamp, so b2 tests the DESIGN against the datasheet inequality,
*   not the part).
*
.model dclamp D(is=1e-12 n=0.01 rs=0.01 cjo=0)
.subckt gopamp inp inn out vp vn
+ params: gbw=1meg aol=1e6 ro=100 vsathi=0.05 vsatlo=0.05 iq=0 islew=1e6
Rin  inp inn 1T
Bgm  0 nint I = min(max({6.283185307*gbw*1e-6}*(V(inp)-V(inn)), -{islew}), {islew})
Rp   nint 0 {aol/(6.283185307*gbw*1e-6)}
Cp   nint 0 1u
Bhi  nhi 0 V = V(vp)-{vsathi}
Blo  nlo 0 V = V(vn)+{vsatlo}
Bawh nawh 0 V = V(nhi)+0.4
Bawl nawl 0 V = V(nlo)-0.4
Dawh nint nawh dclamp
Dawl nawl nint dclamp
Eo   nbuf 0 nint 0 1
Rout nbuf nsen {ro}
Vsen nsen out 0
Dhi  out nhi dclamp
Dlo  nlo out dclamp
Biq  vp vn I = {iq} + max(i(Vsen), 0)
.ends
*
* AD8226 - classic 3-op-amp in-amp built from its OWN published structure so
* that RG, the internal 50k difference-amp network and the REF pin behave the
* way the datasheet describes. pins: +IN -IN RG RG REF OUT +VS -VS
*   preamp gbw 1.83 MHz: Table 3 tabulates bandwidth only at G = 1/10/100/1000
*     (1500/160/20/2 kHz). No G=39.9 row exists; log-log interpolation between
*     the G=10 and G=100 rows gives 45.8 kHz at G1 = 39.9, so preamp
*     GBW = 45.8 kHz * 39.9 = 1.83 MHz. INTERPOLATED, not a cited figure.
*   preamp clamp [-0.35, +VS-0.70] V: Table 8 at TA = +25 degC
*     (V_MINUS_LIMIT -0.35 V, V_PLUS_LIMIT +0.70 V) - the Equation 1/2
*     internal-node boundary, entered by hand.
*   preamp slew 0.6 V/us: Table 3 slew rate, G = 5 to 100.
*   diff-amp gbw 1.5 MHz / slew 0.4 V/us: Table 3 G = 1 rows.
*   diff-amp clamp [0.1, +VS-0.1] V: Table 3 OUTPUT, Output Swing,
*     RL = 10 kohm, TA = -40 to +125 degC.
*   Iq 325 uA: Table 3 quiescent current, 25 degC typ (400 uA max).
*   Ecm: Table 3 CMRR (DC to 60 Hz) is 106 dB min at G=10 and 120 dB min at
*     G=100; there is no G=39.9 row, so the CONSERVATIVE G=10 minimum
*     (106 dB = 5.012e-6 V/V) is injected as a common-mode-to-differential
*     error in series with +IN. Model offset voltage is ZERO: the datasheet
*     gives only maxima (VOSI 100 uV, VOSO 600 uV -> 115 uV RTI -> 16 mV at
*     the board output) and requirements Q7 calibrates initial offset out.
.subckt ad8226 inp inn rga rgb ref out vp vn
Rcm1 inp ncm 10meg
Rcm2 inn ncm 10meg
Ecm  nipe inp ncm 0 5.012e-6
XA1  nipe rga nd1 vp vn gopamp gbw=1.83meg aol=1e6 ro=100 vsathi=0.70 vsatlo=-0.35 islew=0.6
RF1  nd1 rga 24.7k
XA2  inn  rgb nd2 vp vn gopamp gbw=1.83meg aol=1e6 ro=100 vsathi=0.70 vsatlo=-0.35 islew=0.6
RF2  nd2 rgb 24.7k
R11  nd2 na3n 50k
R12  na3n out 50k
R21  nd1 na3p 50k
R22  na3p ref 50k
XA3  na3p na3n out vp vn gopamp gbw=1.5meg aol=1e6 ro=100 vsathi=0.10 vsatlo=0.10 islew=0.4
Iq   vp vn 325u
.ends
*
* The bb-amp signal chain exactly as the board is built.
* pins: IN+ IN- OUT +3V3 GND.  params: cl / rl = the J2 load, ro2333 = the
* OPA2333 open-loop output resistance (see the b10/b11 headers for why it is
* bracketed), riso = an OPTIONAL series isolation resistor between U2B's
* output and J2.
* THE SHIPPING BOARD FITS NO ISOLATION RESISTOR. R6 = 100 R existed at P3 and
* was REMOVED at P4 on the evidence of b11: the OPA2333 Figure 15 overshoot
* curve that motivated it is a UNITY-GAIN measurement, and U2B runs at a
* noise gain of 3.49, where the same calibrated model gives 6.6 % overshoot
* into the full 1 nF with no isolation resistor at all. At `block-only`
* scope, conditioning the datasheet does not require is out of scope, so an
* unnecessary part must not ship. riso = 0.001 ohm IS the shipping circuit (a
* 1 milliohm stand-in for the direct wire, so the element still has a name);
* b10 and b11 sweep riso only to keep the evidence for the removal
* reproducible, and gate ONLY the riso = 0.001 case. This also restores
* blocks.md B5, which had rejected any series output resistor. OPA2333: GBW 350 kHz typ, AOL 130 dB typ (106 dB min) -> 3.16e6,
* output swing 30 mV typ from either rail (RL = 10k, 25 degC; 50 mV max),
* slew 0.16 V/us, IQ 17 uA/channel typ - all TI SBOS351D p.3.
.subckt chain nip nin nout p3v3 gnd
+ params: riso=0.001 cl=1p rl=100k ro2333=1k
XU1  nip nin n_rga n_rgb n_vref n_amp1 p3v3 gnd ad8226
R1   n_rga n_rgb 1.27k
R2   p3v3 n_vrefset 121k
R3   n_vrefset gnd 10k
C4   n_vrefset gnd 100n
XU2A n_vrefset n_vref n_vref p3v3 gnd gopamp gbw=350k aol=3.16e6 ro={ro2333}
+    vsathi=0.030 vsatlo=0.030 iq=17u islew=0.16
XU2B n_amp1 n_fb n_u2bout p3v3 gnd gopamp gbw=350k aol=3.16e6 ro={ro2333}
+    vsathi=0.030 vsatlo=0.030 iq=17u islew=0.16
R4   n_u2bout n_fb 24.9k
R5   n_fb n_vref 10k
RISO n_u2bout nout {riso}
C1   p3v3 gnd 100n
C2   p3v3 gnd 10u
C3   p3v3 gnd 100n
CL   nout gnd {cl}
RL   nout gnd {rl}
.ends
*
* NETLIST CROSS-CHECK (2026-08-16, P4; RE-TAKEN after the R6 removal). These benches were TYPED from
* architecture/blocks.md s1-s2 and constraints.json, not synthesized, because
* schematic-block was authoring the sheet concurrently. As soon as
* kicad/bb-amp.net appeared it was diffed against them with
*   sim_run.py --fragment --net kicad/bb-amp.net --refs R1,R2,R3,R4,R5
* and every value and every connection MATCHES what is modelled here:
*   R1 1.27k across U1 pins 2-3 (/RG_A,/RG_B)  R2 121k  +3V3 -> /VREF_SET
*   R3 10.0k /VREF_SET -> GND                  C4 100n on /VREF_SET
*   R4 24.9k /VOUT -> /FB2                     R5 10.0k /FB2 -> /VREF
*   C1,C3 100n / C2 10u on +3V3                NO R6 - `--refs R6` now
*     answers "refs not in netlist", U2B pin 7 IS /VOUT and drives J2 pin 1
*     directly, and the net /AMP2_OUT no longer exists (R6 removed at P4 by
*     ruling on b11's evidence - see the chain subckt and the b10/b11 heads)
*   U1 REF (pin 6) = /VREF - the BUFFERED node, not the divider, not ground
*   U2A = unity buffer: OUTA = INA- = /VREF, INA+ = /VREF_SET
*   U2B: INB+ = /AMP1_OUT, INB- = /FB2, OUTB = /AMP2_OUT
*   and R5 returns to /VREF, NOT to ground - the one wire blocks.md s2 turns
*   on, and the one a netlist diff is the only way to confirm.
* Net map, bench -> schematic: n_ip=/IN_P n_in=/IN_N n_rga=/RG_A n_rgb=/RG_B
* n_amp1=/AMP1_OUT n_vrefset=/VREF_SET n_vref=/VREF n_fb=/FB2
* n_u2bout and n_out are BOTH /VOUT on the shipping board (they are the two
* ends of the 1 milliohm riso stand-in); p3v3=+3V3 gnd=GND.
* THE CROSS-CHECK IS A SNAPSHOT: these benches carry their own copy of every
* value and will NOT notice a later schematic edit. Re-run the --fragment
* diff above after any change to R1..R5, R2/R3 or the U2 pin assignment.
*
* Sensor source: 350 ohm bridge (requirements Q3) split 175/175, common mode
* pinned at 1.65 V (Q1). V(nd) IS the differential input in volts.
*
* SWEEP PADDING (engine fact, measured on this host, ngspice 46): the FIRST
* point of a .dc sweep is solved from scratch and this 5-op-amp chain can
* land there on a junk operating point (gmin AND source stepping both report
* failure), while `at=` on the LAST point returns 'out of interval'. Every
* .dc and .ac range below is therefore padded so that no measured point is a
* sweep endpoint. Second and later points converge from the previous
* solution and are correct.

.subckt stage2 nin nout p3v3 gnd
+ params: riso=0.001 cl=1n rl=100k ro2333=1k
XU2B nin n_fb n_u2bout p3v3 gnd gopamp gbw=350k aol=3.16e6 ro={ro2333}
+    vsathi=0.030 vsatlo=0.030 iq=17u islew=0.16
R4   n_u2bout n_fb 24.9k
R5   n_fb n_vref 10k
Vref n_vref gnd DC 0.2519
RISO n_u2bout nout {riso}
CL   nout gnd {cl}
RL   nout gnd {rl}
.ends
.temp 25
VS   p3v3 0 DC 3.3
Vst  nstep 0 PWL(0 0.30 20u 0.30 20.1u 0.32 200u 0.32)
* --- Figure-15 calibration: PLAIN unity-gain buffers, CL on the pin ---
Xub1  nstep ub1o ub1o p3v3 0 gopamp gbw=350k aol=3.16e6 ro=1k vsathi=0.030 vsatlo=0.030 iq=17u islew=0.16
Cub1 ub1o 0 100p
Rub1 ub1o 0 100k
Xub2  nstep ub2o ub2o p3v3 0 gopamp gbw=350k aol=3.16e6 ro=1k vsathi=0.030 vsatlo=0.030 iq=17u islew=0.16
Cub2 ub2o 0 1n
Rub2 ub2o 0 100k
Xub3  nstep ub3o ub3o p3v3 0 gopamp gbw=350k aol=3.16e6 ro=2k vsathi=0.030 vsatlo=0.030 iq=17u islew=0.16
Cub3 ub3o 0 100p
Rub3 ub3o 0 100k
Xub4  nstep ub4o ub4o p3v3 0 gopamp gbw=350k aol=3.16e6 ro=2k vsathi=0.030 vsatlo=0.030 iq=17u islew=0.16
Cub4 ub4o 0 1n
Rub4 ub4o 0 100k
* --- the real U2B stage (G2 = 3.49) into 1 nF, R6 swept ---
Xs_r0  nstep s_r0o p3v3 0 stage2 riso=0.001 cl=1n rl=100k ro2333=1k
Xs_r47  nstep s_r47o p3v3 0 stage2 riso=47 cl=1n rl=100k ro2333=1k
Xs_r100  nstep s_r100o p3v3 0 stage2 riso=100 cl=1n rl=100k ro2333=1k
Xs_r220  nstep s_r220o p3v3 0 stage2 riso=220 cl=1n rl=100k ro2333=1k
Xs_r470  nstep s_r470o p3v3 0 stage2 riso=470 cl=1n rl=100k ro2333=1k
Xs_r1k  nstep s_r1ko p3v3 0 stage2 riso=1000 cl=1n rl=100k ro2333=1k
Xt_r0  nstep t_r0o p3v3 0 stage2 riso=0.001 cl=1n rl=100k ro2333=2k
Xt_r47  nstep t_r47o p3v3 0 stage2 riso=47 cl=1n rl=100k ro2333=2k
Xt_r100  nstep t_r100o p3v3 0 stage2 riso=100 cl=1n rl=100k ro2333=2k
Xt_r220  nstep t_r220o p3v3 0 stage2 riso=220 cl=1n rl=100k ro2333=2k
Xt_r470  nstep t_r470o p3v3 0 stage2 riso=470 cl=1n rl=100k ro2333=2k
Xt_r1k  nstep t_r1ko p3v3 0 stage2 riso=1000 cl=1n rl=100k ro2333=2k
Xs_nc  nstep s_nco p3v3 0 stage2 riso=0.001 cl=1p rl=100k ro2333=1k
Xt_nc  nstep t_nco p3v3 0 stage2 riso=0.001 cl=1p rl=100k ro2333=2k
.tran 5n 200u
.meas tran lo_ub1 find v(ub1o) at=19u
.meas tran fs_ub1 find v(ub1o) at=190u
.meas tran pk_ub1 max  v(ub1o) from=20u to=120u
.meas tran os_ub1 param='(pk_ub1-fs_ub1)/(fs_ub1-lo_ub1)*100'
.meas tran lo_ub2 find v(ub2o) at=19u
.meas tran fs_ub2 find v(ub2o) at=190u
.meas tran pk_ub2 max  v(ub2o) from=20u to=120u
.meas tran os_ub2 param='(pk_ub2-fs_ub2)/(fs_ub2-lo_ub2)*100'
.meas tran lo_ub3 find v(ub3o) at=19u
.meas tran fs_ub3 find v(ub3o) at=190u
.meas tran pk_ub3 max  v(ub3o) from=20u to=120u
.meas tran os_ub3 param='(pk_ub3-fs_ub3)/(fs_ub3-lo_ub3)*100'
.meas tran lo_ub4 find v(ub4o) at=19u
.meas tran fs_ub4 find v(ub4o) at=190u
.meas tran pk_ub4 max  v(ub4o) from=20u to=120u
.meas tran os_ub4 param='(pk_ub4-fs_ub4)/(fs_ub4-lo_ub4)*100'
.meas tran lo_s_r0 find v(s_r0o) at=19u
.meas tran fs_s_r0 find v(s_r0o) at=190u
.meas tran pk_s_r0 max  v(s_r0o) from=20u to=120u
.meas tran os_s_r0 param='(pk_s_r0-fs_s_r0)/(fs_s_r0-lo_s_r0)*100'
.meas tran lo_s_r47 find v(s_r47o) at=19u
.meas tran fs_s_r47 find v(s_r47o) at=190u
.meas tran pk_s_r47 max  v(s_r47o) from=20u to=120u
.meas tran os_s_r47 param='(pk_s_r47-fs_s_r47)/(fs_s_r47-lo_s_r47)*100'
.meas tran lo_s_r100 find v(s_r100o) at=19u
.meas tran fs_s_r100 find v(s_r100o) at=190u
.meas tran pk_s_r100 max  v(s_r100o) from=20u to=120u
.meas tran os_s_r100 param='(pk_s_r100-fs_s_r100)/(fs_s_r100-lo_s_r100)*100'
.meas tran lo_s_r220 find v(s_r220o) at=19u
.meas tran fs_s_r220 find v(s_r220o) at=190u
.meas tran pk_s_r220 max  v(s_r220o) from=20u to=120u
.meas tran os_s_r220 param='(pk_s_r220-fs_s_r220)/(fs_s_r220-lo_s_r220)*100'
.meas tran lo_s_r470 find v(s_r470o) at=19u
.meas tran fs_s_r470 find v(s_r470o) at=190u
.meas tran pk_s_r470 max  v(s_r470o) from=20u to=120u
.meas tran os_s_r470 param='(pk_s_r470-fs_s_r470)/(fs_s_r470-lo_s_r470)*100'
.meas tran lo_s_r1k find v(s_r1ko) at=19u
.meas tran fs_s_r1k find v(s_r1ko) at=190u
.meas tran pk_s_r1k max  v(s_r1ko) from=20u to=120u
.meas tran os_s_r1k param='(pk_s_r1k-fs_s_r1k)/(fs_s_r1k-lo_s_r1k)*100'
.meas tran lo_t_r0 find v(t_r0o) at=19u
.meas tran fs_t_r0 find v(t_r0o) at=190u
.meas tran pk_t_r0 max  v(t_r0o) from=20u to=120u
.meas tran os_t_r0 param='(pk_t_r0-fs_t_r0)/(fs_t_r0-lo_t_r0)*100'
.meas tran lo_t_r47 find v(t_r47o) at=19u
.meas tran fs_t_r47 find v(t_r47o) at=190u
.meas tran pk_t_r47 max  v(t_r47o) from=20u to=120u
.meas tran os_t_r47 param='(pk_t_r47-fs_t_r47)/(fs_t_r47-lo_t_r47)*100'
.meas tran lo_t_r100 find v(t_r100o) at=19u
.meas tran fs_t_r100 find v(t_r100o) at=190u
.meas tran pk_t_r100 max  v(t_r100o) from=20u to=120u
.meas tran os_t_r100 param='(pk_t_r100-fs_t_r100)/(fs_t_r100-lo_t_r100)*100'
.meas tran lo_t_r220 find v(t_r220o) at=19u
.meas tran fs_t_r220 find v(t_r220o) at=190u
.meas tran pk_t_r220 max  v(t_r220o) from=20u to=120u
.meas tran os_t_r220 param='(pk_t_r220-fs_t_r220)/(fs_t_r220-lo_t_r220)*100'
.meas tran lo_t_r470 find v(t_r470o) at=19u
.meas tran fs_t_r470 find v(t_r470o) at=190u
.meas tran pk_t_r470 max  v(t_r470o) from=20u to=120u
.meas tran os_t_r470 param='(pk_t_r470-fs_t_r470)/(fs_t_r470-lo_t_r470)*100'
.meas tran lo_t_r1k find v(t_r1ko) at=19u
.meas tran fs_t_r1k find v(t_r1ko) at=190u
.meas tran pk_t_r1k max  v(t_r1ko) from=20u to=120u
.meas tran os_t_r1k param='(pk_t_r1k-fs_t_r1k)/(fs_t_r1k-lo_t_r1k)*100'
.meas tran lo_s_nc find v(s_nco) at=19u
.meas tran fs_s_nc find v(s_nco) at=190u
.meas tran pk_s_nc max  v(s_nco) from=20u to=120u
.meas tran os_s_nc param='(pk_s_nc-fs_s_nc)/(fs_s_nc-lo_s_nc)*100'
.meas tran lo_t_nc find v(t_nco) at=19u
.meas tran fs_t_nc find v(t_nco) at=190u
.meas tran pk_t_nc max  v(t_nco) from=20u to=120u
.meas tran os_t_nc param='(pk_t_nc-fs_t_nc)/(fs_t_nc-lo_t_nc)*100'
.meas tran d_a param='os_s_r0-os_s_r1k'
.meas tran d_b param='os_t_r0-os_t_r1k'
.end
